* Extracted by KLayout with SG13G2 LVS runset on : 05/10/2026 19:38

.SUBCKT nssoc_clock_div4_v7_layout SUB AVSS DIV_AVDD CLKN CLKP QN QP
R$1 DIV_AVDD \$8 \$1 rppd w=1u l=4u ps=0u b=0 m=1
R$2 DIV_AVDD \$7 \$1 rppd w=1u l=4u ps=0u b=0 m=1
R$3 CLKP \$8 \$1 rppd w=4u l=3.6u ps=0u b=0 m=1
R$4 CLKN \$7 \$1 rppd w=4u l=3.6u ps=0u b=0 m=1
C$5 \$150 \$194 cap_cmim w=20u l=20u A=400p P=80u m=1
C$6 \$133 \$191 cap_cmim w=20u l=20u A=400p P=80u m=1
R$7 \$191 AVSS \$1 rppd w=1u l=7u ps=0u b=0 m=1
R$8 \$194 AVSS \$1 rppd w=1u l=7u ps=0u b=0 m=1
R$9 \$125 AVSS \$1 rppd w=1u l=16u ps=0u b=0 m=1
R$10 \$113 AVSS \$1 rppd w=1u l=16u ps=0u b=0 m=1
R$11 \$3 \$125 \$1 rppd w=2u l=3.6u ps=0u b=0 m=1
R$12 \$4 \$113 \$1 rppd w=2u l=3.6u ps=0u b=0 m=1
R$13 DIV_AVDD \$136 \$1 rppd w=1u l=9u ps=0u b=0 m=1
R$14 DIV_AVDD \$133 \$1 rppd w=8u l=4.4u ps=0u b=0 m=1
R$15 DIV_AVDD \$150 \$1 rppd w=8u l=4.4u ps=0u b=0 m=1
R$16 \$133 \$191 \$1 rppd w=2u l=8u ps=0u b=0 m=1
R$17 \$150 \$194 \$1 rppd w=2u l=8u ps=0u b=0 m=1
C$18 \$6 AVSS cap_cmim w=2u l=2u A=4p P=8u m=1
C$19 \$277 AVSS cap_cmim w=2u l=2u A=4p P=8u m=1
C$20 \$5 AVSS cap_cmim w=2.2u l=2u A=4.4p P=8.4u m=1
C$21 \$276 AVSS cap_cmim w=2.2u l=2u A=4.4p P=8.4u m=1
R$22 DIV_AVDD \$273 \$1 rppd w=1u l=12.7u ps=0u b=0 m=1
R$23 DIV_AVDD \$2 \$1 rppd w=1u l=12.7u ps=0u b=0 m=1
Q$24 \$273 \$273 AVSS \$1 npn13G2 we=70n le=900n Nx=1 m=1
Q$25 \$136 \$136 AVSS \$1 npn13G2 we=70n le=900n Nx=1 m=1
Q$26 \$2 \$2 AVSS \$1 npn13G2 we=70n le=900n Nx=1 m=1
R$27 DIV_AVDD QP \$1 rppd w=8u l=2.12u ps=0u b=0 m=1
R$28 DIV_AVDD \$5 \$1 rppd w=8u l=2.12u ps=0u b=0 m=1
R$29 DIV_AVDD \$276 \$1 rppd w=8u l=2.12u ps=0u b=0 m=1
R$30 DIV_AVDD QN \$1 rppd w=8u l=2.12u ps=0u b=0 m=1
R$31 DIV_AVDD \$4 \$1 rppd w=8u l=2.12u ps=0u b=0 m=1
R$32 DIV_AVDD \$6 \$1 rppd w=8u l=2.12u ps=0u b=0 m=1
R$33 DIV_AVDD \$277 \$1 rppd w=8u l=2.12u ps=0u b=0 m=1
R$34 DIV_AVDD \$3 \$1 rppd w=8u l=2.12u ps=0u b=0 m=1
Q$35 \$50 \$2 AVSS \$1 npn13G2 we=70n le=900n Nx=4 m=1
Q$36 \$322 \$273 AVSS \$1 npn13G2 we=70n le=900n Nx=4 m=1
Q$37 \$61 \$7 \$82 \$1 npn13G2 we=70n le=900n Nx=4 m=1
Q$38 \$366 \$273 AVSS \$1 npn13G2 we=70n le=900n Nx=4 m=1
Q$39 \$355 \$194 \$366 \$1 npn13G2 we=70n le=900n Nx=4 m=1
Q$40 \$33 \$8 \$50 \$1 npn13G2 we=70n le=900n Nx=4 m=1
Q$41 \$316 \$194 \$322 \$1 npn13G2 we=70n le=900n Nx=4 m=1
Q$42 \$37 \$7 \$50 \$1 npn13G2 we=70n le=900n Nx=4 m=1
Q$43 \$300 \$191 \$322 \$1 npn13G2 we=70n le=900n Nx=4 m=1
Q$44 \$75 \$8 \$82 \$1 npn13G2 we=70n le=900n Nx=4 m=1
Q$45 \$352 \$191 \$366 \$1 npn13G2 we=70n le=900n Nx=4 m=1
Q$46 \$128 \$136 AVSS \$1 npn13G2 we=70n le=900n Nx=4 m=1
Q$47 \$82 \$2 AVSS \$1 npn13G2 we=70n le=900n Nx=4 m=1
R$48 SUB \$1 ptap1 A=72p P=144u
Q$66 \$133 \$113 \$128 \$1 npn13G2 we=70n le=900n Nx=2 m=1
Q$67 \$276 QP \$352 \$1 npn13G2 we=70n le=900n Nx=2 m=1
Q$68 QP QN \$300 \$1 npn13G2 we=70n le=900n Nx=2 m=1
Q$69 \$150 \$125 \$128 \$1 npn13G2 we=70n le=900n Nx=2 m=1
Q$70 \$5 \$6 \$75 \$1 npn13G2 we=70n le=900n Nx=2 m=1
Q$71 \$6 \$3 \$61 \$1 npn13G2 we=70n le=900n Nx=2 m=1
Q$72 \$276 \$277 \$355 \$1 npn13G2 we=70n le=900n Nx=2 m=1
Q$73 \$3 \$5 \$33 \$1 npn13G2 we=70n le=900n Nx=2 m=1
Q$74 \$3 \$4 \$37 \$1 npn13G2 we=70n le=900n Nx=2 m=1
Q$75 QN QP \$300 \$1 npn13G2 we=70n le=900n Nx=2 m=1
Q$76 \$277 \$276 \$355 \$1 npn13G2 we=70n le=900n Nx=2 m=1
Q$77 \$277 QN \$352 \$1 npn13G2 we=70n le=900n Nx=2 m=1
Q$78 \$4 \$6 \$33 \$1 npn13G2 we=70n le=900n Nx=2 m=1
Q$79 \$6 \$5 \$75 \$1 npn13G2 we=70n le=900n Nx=2 m=1
Q$80 QP \$277 \$316 \$1 npn13G2 we=70n le=900n Nx=2 m=1
Q$81 QN \$276 \$316 \$1 npn13G2 we=70n le=900n Nx=2 m=1
Q$82 \$5 \$4 \$61 \$1 npn13G2 we=70n le=900n Nx=2 m=1
Q$83 \$4 \$3 \$37 \$1 npn13G2 we=70n le=900n Nx=2 m=1
R$84 \$37 AVSS \$1 rppd w=1u l=38.4u ps=0u b=0 m=1
R$85 \$316 AVSS \$1 rppd w=1u l=38.4u ps=0u b=0 m=1
R$86 \$300 AVSS \$1 rppd w=1u l=38.4u ps=0u b=0 m=1
R$87 \$75 AVSS \$1 rppd w=1u l=38.4u ps=0u b=0 m=1
R$88 \$61 AVSS \$1 rppd w=1u l=38.4u ps=0u b=0 m=1
R$89 \$355 AVSS \$1 rppd w=1u l=38.4u ps=0u b=0 m=1
R$90 \$33 AVSS \$1 rppd w=1u l=38.4u ps=0u b=0 m=1
R$91 \$352 AVSS \$1 rppd w=1u l=38.4u ps=0u b=0 m=1
.ENDS nssoc_clock_div4_v7_layout
