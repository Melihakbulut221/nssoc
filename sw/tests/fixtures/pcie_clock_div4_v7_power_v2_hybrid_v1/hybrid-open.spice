* Exact 91-device / 205-anchor integration PILOT. NOT closed body PEX.
* BODY_SUBSTRATE requires an explicit external boundary assumption.
* WIRE_CREF is NOT mapped to an intrinsic body/supply.
.subckt nssoc_clock_div4_v7_power_v2_hybrid_open_v1 AVSS CLKN CLKP DIV_AVDD QN QP SUB BODY_SUBSTRATE WIRE_CREF
XD0001 w_T0000 w_T0001 w_T0002 BODY_SUBSTRATE npn13G2 Nx=4 we=0.07u le=0.9u
XD0002 w_T0004 w_T0005 w_T0006 BODY_SUBSTRATE npn13G2 Nx=4 we=0.07u le=0.9u
XD0003 w_T0008 w_T0009 w_T0010 BODY_SUBSTRATE npn13G2 Nx=4 we=0.07u le=0.9u
XD0004 w_T0012 w_T0013 w_T0014 BODY_SUBSTRATE npn13G2 Nx=2 we=0.07u le=0.9u
XD0005 w_T0016 w_T0017 w_T0018 BODY_SUBSTRATE npn13G2 Nx=2 we=0.07u le=0.9u
XD0006 w_T0020 w_T0021 w_T0022 BODY_SUBSTRATE npn13G2 Nx=2 we=0.07u le=0.9u
XD0007 w_T0024 w_T0025 w_T0026 BODY_SUBSTRATE npn13G2 Nx=4 we=0.07u le=0.9u
XD0008 w_T0028 w_T0029 w_T0030 BODY_SUBSTRATE npn13G2 Nx=4 we=0.07u le=0.9u
XD0009 w_T0032 w_T0033 w_T0034 BODY_SUBSTRATE npn13G2 Nx=4 we=0.07u le=0.9u
XD0010 w_T0036 w_T0037 w_T0038 BODY_SUBSTRATE npn13G2 Nx=2 we=0.07u le=0.9u
XD0011 w_T0040 w_T0041 w_T0042 BODY_SUBSTRATE npn13G2 Nx=2 we=0.07u le=0.9u
XD0012 w_T0044 w_T0045 w_T0046 BODY_SUBSTRATE npn13G2 Nx=2 we=0.07u le=0.9u
XD0013 w_T0048 w_T0049 w_T0050 BODY_SUBSTRATE npn13G2 Nx=2 we=0.07u le=0.9u
XD0014 w_T0052 w_T0053 w_T0054 BODY_SUBSTRATE npn13G2 Nx=1 we=0.07u le=0.9u
XD0015 w_T0056 w_T0057 w_T0058 BODY_SUBSTRATE npn13G2 Nx=2 we=0.07u le=0.9u
XD0016 w_T0060 w_T0061 w_T0062 BODY_SUBSTRATE npn13G2 Nx=1 we=0.07u le=0.9u
XD0017 w_T0064 w_T0065 w_T0066 BODY_SUBSTRATE npn13G2 Nx=4 we=0.07u le=0.9u
XD0018 w_T0068 w_T0069 w_T0070 BODY_SUBSTRATE npn13G2 Nx=2 we=0.07u le=0.9u
XD0019 w_T0072 w_T0073 w_T0074 BODY_SUBSTRATE npn13G2 Nx=2 we=0.07u le=0.9u
XD0020 w_T0076 w_T0077 w_T0078 BODY_SUBSTRATE npn13G2 Nx=4 we=0.07u le=0.9u
XD0021 w_T0080 w_T0081 w_T0082 BODY_SUBSTRATE npn13G2 Nx=4 we=0.07u le=0.9u
XD0022 w_T0084 w_T0085 w_T0086 BODY_SUBSTRATE npn13G2 Nx=4 we=0.07u le=0.9u
XD0023 w_T0088 w_T0089 w_T0090 BODY_SUBSTRATE npn13G2 Nx=2 we=0.07u le=0.9u
XD0024 w_T0092 w_T0093 w_T0094 BODY_SUBSTRATE npn13G2 Nx=2 we=0.07u le=0.9u
XD0025 w_T0096 w_T0097 w_T0098 BODY_SUBSTRATE npn13G2 Nx=2 we=0.07u le=0.9u
XD0026 w_T0100 w_T0101 w_T0102 BODY_SUBSTRATE npn13G2 Nx=4 we=0.07u le=0.9u
XD0027 w_T0104 w_T0105 w_T0106 BODY_SUBSTRATE npn13G2 Nx=4 we=0.07u le=0.9u
XD0028 w_T0108 w_T0109 w_T0110 BODY_SUBSTRATE npn13G2 Nx=4 we=0.07u le=0.9u
XD0029 w_T0112 w_T0113 w_T0114 BODY_SUBSTRATE npn13G2 Nx=2 we=0.07u le=0.9u
XD0030 w_T0116 w_T0117 w_T0118 BODY_SUBSTRATE npn13G2 Nx=2 we=0.07u le=0.9u
XD0031 w_T0120 w_T0121 w_T0122 BODY_SUBSTRATE npn13G2 Nx=2 we=0.07u le=0.9u
XD0032 w_T0124 w_T0125 w_T0126 BODY_SUBSTRATE npn13G2 Nx=2 we=0.07u le=0.9u
XD0033 w_T0128 w_T0129 w_T0130 BODY_SUBSTRATE npn13G2 Nx=1 we=0.07u le=0.9u
XD0034 w_T0132 w_T0133 w_T0134 BODY_SUBSTRATE npn13G2 Nx=2 we=0.07u le=0.9u
XD0035 w_T0136 w_T0137 BODY_SUBSTRATE rppd w=1.0u l=38.4u ps=0.0u b=0 m=1 sw_et=1
XD0036 w_T0139 w_T0140 BODY_SUBSTRATE rppd w=1.0u l=38.4u ps=0.0u b=0 m=1 sw_et=1
XD0037 w_T0142 w_T0143 BODY_SUBSTRATE rppd w=8.0u l=2.12u ps=0.0u b=0 m=1 sw_et=1
XD0038 w_T0145 w_T0146 BODY_SUBSTRATE rppd w=8.0u l=2.12u ps=0.0u b=0 m=1 sw_et=1
XD0039 w_T0148 w_T0149 BODY_SUBSTRATE rppd w=1.0u l=38.4u ps=0.0u b=0 m=1 sw_et=1
XD0040 w_T0151 w_T0152 BODY_SUBSTRATE rppd w=1.0u l=38.4u ps=0.0u b=0 m=1 sw_et=1
XD0041 w_T0154 w_T0155 BODY_SUBSTRATE rppd w=8.0u l=2.12u ps=0.0u b=0 m=1 sw_et=1
XD0042 w_T0157 w_T0158 BODY_SUBSTRATE rppd w=8.0u l=2.12u ps=0.0u b=0 m=1 sw_et=1
XD0043 w_T0160 w_T0161 BODY_SUBSTRATE rppd w=1.0u l=12.7u ps=0.0u b=0 m=1 sw_et=1
XD0044 w_T0163 w_T0164 BODY_SUBSTRATE rppd w=1.0u l=4.0u ps=0.0u b=0 m=1 sw_et=1
XD0045 w_T0166 w_T0167 BODY_SUBSTRATE rppd w=1.0u l=4.0u ps=0.0u b=0 m=1 sw_et=1
XD0046 w_T0169 w_T0170 BODY_SUBSTRATE rppd w=4.0u l=3.6u ps=0.0u b=0 m=1 sw_et=1
XD0047 w_T0172 w_T0173 BODY_SUBSTRATE rppd w=4.0u l=3.6u ps=0.0u b=0 m=1 sw_et=1
XD0048 w_T0175 w_T0176 BODY_SUBSTRATE rppd w=2.0u l=3.6u ps=0.0u b=0 m=1 sw_et=1
XD0049 w_T0178 w_T0179 BODY_SUBSTRATE rppd w=2.0u l=3.6u ps=0.0u b=0 m=1 sw_et=1
XD0050 w_T0181 w_T0182 BODY_SUBSTRATE rppd w=1.0u l=16.0u ps=0.0u b=0 m=1 sw_et=1
XD0051 w_T0184 w_T0185 BODY_SUBSTRATE rppd w=1.0u l=16.0u ps=0.0u b=0 m=1 sw_et=1
XD0052 w_T0187 w_T0188 BODY_SUBSTRATE rppd w=1.0u l=9.0u ps=0.0u b=0 m=1 sw_et=1
XD0053 w_T0190 w_T0191 BODY_SUBSTRATE rppd w=8.0u l=4.4u ps=0.0u b=0 m=1 sw_et=1
XD0054 w_T0193 w_T0194 BODY_SUBSTRATE rppd w=8.0u l=4.4u ps=0.0u b=0 m=1 sw_et=1
XD0055 w_T0196 w_T0197 BODY_SUBSTRATE rppd w=2.0u l=8.0u ps=0.0u b=0 m=1 sw_et=1
XD0056 w_T0199 w_T0200 BODY_SUBSTRATE rppd w=2.0u l=8.0u ps=0.0u b=0 m=1 sw_et=1
XD0057 w_T0202 w_T0203 BODY_SUBSTRATE rppd w=1.0u l=7.0u ps=0.0u b=0 m=1 sw_et=1
XD0058 w_T0205 w_T0206 BODY_SUBSTRATE rppd w=1.0u l=7.0u ps=0.0u b=0 m=1 sw_et=1
XD0059 w_T0208 w_T0209 BODY_SUBSTRATE rppd w=1.0u l=38.4u ps=0.0u b=0 m=1 sw_et=1
XD0060 w_T0211 w_T0212 BODY_SUBSTRATE rppd w=1.0u l=38.4u ps=0.0u b=0 m=1 sw_et=1
XD0061 w_T0214 w_T0215 BODY_SUBSTRATE rppd w=8.0u l=2.12u ps=0.0u b=0 m=1 sw_et=1
XD0062 w_T0217 w_T0218 BODY_SUBSTRATE rppd w=8.0u l=2.12u ps=0.0u b=0 m=1 sw_et=1
XD0063 w_T0220 w_T0221 BODY_SUBSTRATE rppd w=1.0u l=38.4u ps=0.0u b=0 m=1 sw_et=1
XD0064 w_T0223 w_T0224 BODY_SUBSTRATE rppd w=1.0u l=38.4u ps=0.0u b=0 m=1 sw_et=1
XD0065 w_T0226 w_T0227 BODY_SUBSTRATE rppd w=8.0u l=2.12u ps=0.0u b=0 m=1 sw_et=1
XD0066 w_T0229 w_T0230 BODY_SUBSTRATE rppd w=8.0u l=2.12u ps=0.0u b=0 m=1 sw_et=1
XD0067 w_T0232 w_T0233 BODY_SUBSTRATE rppd w=1.0u l=12.7u ps=0.0u b=0 m=1 sw_et=1
XD0068 w_T0235 w_T0236 cap_cmim w=2.0u l=2.0u
XD0069 w_T0237 w_T0238 cap_cmim w=2.2u l=2.0u
XD0070 w_T0239 w_T0240 cap_cmim w=20.0u l=20.0u
XD0071 w_T0241 w_T0242 cap_cmim w=20.0u l=20.0u
XD0072 w_T0243 w_T0244 cap_cmim w=2.0u l=2.0u
XD0073 w_T0245 w_T0246 cap_cmim w=2.2u l=2.0u
XD0074 w_T0247 BODY_SUBSTRATE ptap1 R=81.66666666666666666666666668 w=2u l=2u
XD0075 w_T0249 BODY_SUBSTRATE ptap1 R=81.66666666666666666666666668 w=2u l=2u
XD0076 w_T0251 BODY_SUBSTRATE ptap1 R=81.66666666666666666666666668 w=2u l=2u
XD0077 w_T0253 BODY_SUBSTRATE ptap1 R=81.66666666666666666666666668 w=2u l=2u
XD0078 w_T0255 BODY_SUBSTRATE ptap1 R=81.66666666666666666666666668 w=2u l=2u
XD0079 w_T0257 BODY_SUBSTRATE ptap1 R=81.66666666666666666666666668 w=2u l=2u
XD0080 w_T0259 BODY_SUBSTRATE ptap1 R=81.66666666666666666666666668 w=2u l=2u
XD0081 w_T0261 BODY_SUBSTRATE ptap1 R=81.66666666666666666666666668 w=2u l=2u
XD0082 w_T0263 BODY_SUBSTRATE ptap1 R=81.66666666666666666666666668 w=2u l=2u
XD0083 w_T0265 BODY_SUBSTRATE ptap1 R=81.66666666666666666666666668 w=2u l=2u
XD0084 w_T0267 BODY_SUBSTRATE ptap1 R=81.66666666666666666666666668 w=2u l=2u
XD0085 w_T0269 BODY_SUBSTRATE ptap1 R=81.66666666666666666666666668 w=2u l=2u
XD0086 w_T0271 BODY_SUBSTRATE ptap1 R=81.66666666666666666666666668 w=2u l=2u
XD0087 w_T0273 BODY_SUBSTRATE ptap1 R=81.66666666666666666666666668 w=2u l=2u
XD0088 w_T0275 BODY_SUBSTRATE ptap1 R=81.66666666666666666666666668 w=2u l=2u
XD0089 w_T0277 BODY_SUBSTRATE ptap1 R=81.66666666666666666666666668 w=2u l=2u
XD0090 w_T0279 BODY_SUBSTRATE ptap1 R=81.66666666666666666666666668 w=2u l=2u
XD0091 w_T0281 BODY_SUBSTRATE ptap1 R=81.66666666666666666666666668 w=2u l=2u
R0 CLKP w_T0172 29.4381
R1 CLKN w_T0169 31.9314
R2 w_T0151.n0 w_T0151 9
R3 w_T0151 w_T0151.n1 42.7852
R4 w_T0151.n1 w_T0151.n2 5.544
R5 w_T0050 w_T0151.n2 28.4887
R6 w_T0046 w_T0151.n2 26.7287
R7 w_T0151.n1 w_T0032 30.6467
R8 w_T0148.n0 w_T0148 9
R9 w_T0148 w_T0148.n1 42.0519
R10 w_T0148.n1 w_T0148.n2 3.784
R11 w_T0042 w_T0148.n2 27.7554
R12 w_T0038 w_T0148.n2 25.9954
R13 w_T0148.n1 w_T0028 29.9133
R14 w_T0034.n0 w_T0034 29.6291
R15 w_T0030 w_T0034.n0 27.8691
R16 w_T0034.n0 w_T0024 33.404
R17 w_T0139.n0 w_T0139 9
R18 w_T0139 w_T0139.n1 44.9852
R19 w_T0139.n1 w_T0139.n2 5.544
R20 w_T0058 w_T0139.n2 30.6887
R21 w_T0022 w_T0139.n2 28.9287
R22 w_T0139.n1 w_T0008 32.8467
R23 w_T0136.n0 w_T0136 9
R24 w_T0136 w_T0136.n1 44.2519
R25 w_T0136.n1 w_T0136.n2 3.784
R26 w_T0018 w_T0136.n2 29.9554
R27 w_T0014 w_T0136.n2 28.1954
R28 w_T0136.n1 w_T0004 32.1133
R29 w_T0010.n0 w_T0010 31.8291
R30 w_T0006 w_T0010.n0 30.0691
R31 w_T0010.n0 w_T0000 35.604
R32 w_T0237 w_T0237.n0 42.0611
R33 w_T0237.n1 w_T0237.n0 7.172
R34 w_T0237.n2 w_T0237.n1 6.776
R35 w_T0237.n3 w_T0237.n2 1.892
R36 w_T0044 w_T0237.n3 29.6677
R37 w_T0237.n3 w_T0041 27.5799
R38 w_T0237.n2 w_T0036 28.0397
R39 w_T0237.n1 w_T0158 27.3349
R40 w_T0237.n0 w_T0057 27.5799
R41 w_T0235 w_T0235.n0 41.327
R42 w_T0235.n1 w_T0235.n0 7.172
R43 w_T0235.n2 w_T0235.n1 8.668
R44 w_T0235.n3 w_T0235.n2 1.628
R45 w_T0048 w_T0235.n3 30.8263
R46 w_T0235.n3 w_T0040 27.3063
R47 w_T0235.n2 w_T0037 26.8465
R48 w_T0235.n1 w_T0155 26.6016
R49 w_T0235.n0 w_T0021 26.8465
R50 w_T0173.n1 w_T0173 28.8397
R51 w_T0173.n1 w_T0173.n0 15.972
R52 w_T0167 w_T0173.n1 29.4561
R53 w_T0173.n0 w_T0029 26.5202
R54 w_T0173.n0 w_T0009 44.1202
R55 w_T0170.n1 w_T0170 28.1064
R56 w_T0170.n1 w_T0170.n0 12.452
R57 w_T0164 w_T0170.n1 28.7228
R58 w_T0170.n0 w_T0033 25.7869
R59 w_T0170.n0 w_T0005 46.9069
R60 w_T0161.n0 w_T0161 9
R61 w_T0161 w_T0161.n3 32.9101
R62 w_T0161.n2 w_T0161.n1 12.188
R63 w_T0161.n3 w_T0161.n2 0.132
R64 w_T0161.n3 w_T0053 28.1097
R65 w_T0161.n2 w_T0052 28.5974
R66 w_T0161.n1 w_T0025 28.7202
R67 w_T0161.n1 w_T0001 48.0802
R68 w_T0178.n0 w_T0178 84.066
R69 w_T0178.n1 w_T0178.n0 8.668
R70 w_T0178.n2 w_T0178.n1 1.628
R71 w_T0178.n3 w_T0178.n2 3.52
R72 w_T0049 w_T0178.n3 43.4052
R73 w_T0178.n3 w_T0056 24.373
R74 w_T0178.n2 w_T0016 24.373
R75 w_T0178.n1 w_T0013 23.9132
R76 w_T0178.n0 w_T0143 23.6682
R77 w_T0175.n0 w_T0175 84.4474
R78 w_T0175.n1 w_T0175.n0 6.776
R79 w_T0175.n2 w_T0175.n1 1.892
R80 w_T0175.n3 w_T0175.n2 1.628
R81 w_T0045 w_T0175.n3 44.1385
R82 w_T0175.n3 w_T0020 25.1063
R83 w_T0175.n2 w_T0017 24.6465
R84 w_T0175.n1 w_T0012 25.1063
R85 w_T0175.n0 w_T0146 24.4016
R86 w_T0084.n0 w_T0084 29.9426
R87 w_T0074 w_T0084.n0 24.5287
R88 w_T0070 w_T0084.n0 26.2887
R89 w_T0184.n0 w_T0184 9
R90 w_T0184 w_T0184.n1 26.7839
R91 w_T0184.n1 w_T0073 29.4865
R92 w_T0184.n1 w_T0179 24.821
R93 w_T0181.n0 w_T0181 9
R94 w_T0181 w_T0181.n1 27.5172
R95 w_T0181.n1 w_T0069 30.2199
R96 w_T0181.n1 w_T0176 25.5544
R97 w_T0241 w_T0241.n1 26.622
R98 w_T0241.n1 w_T0241.n0 3.388
R99 w_T0199 w_T0241.n1 25.3314
R100 w_T0241.n0 w_T0194 24.9677
R101 w_T0241.n0 w_T0068 33.1437
R102 w_T0239 w_T0239.n1 27.3553
R103 w_T0239.n1 w_T0239.n0 3.388
R104 w_T0196 w_T0239.n1 26.0648
R105 w_T0239.n0 w_T0191 25.701
R106 w_T0239.n0 w_T0072 30.357
R107 w_T0188.n0 w_T0188 9
R108 w_T0188 w_T0188.n1 31.3188
R109 w_T0188.n1 w_T0188.n2 0.132
R110 w_T0188.n2 w_T0085 32.5335
R111 w_T0188.n2 w_T0061 26.643
R112 w_T0188.n1 w_T0060 27.1307
R113 SUB w_P006.n11 0.836
R114 w_P006.n12 w_P006.n11 7.084
R115 w_P006.n13 w_P006.n12 8.8
R116 w_P006.n14 w_P006.n13 8.8
R117 w_P006.n15 w_P006.n14 8.8
R118 w_P006.n16 w_P006.n15 8.8
R119 w_T0257 w_P006.n16 28.5225
R120 w_T0255 w_P006.n16 19.7225
R121 w_T0253 w_P006.n15 19.7225
R122 w_T0251 w_P006.n14 19.7225
R123 w_T0249 w_P006.n13 19.7225
R124 w_T0247 w_P006.n12 19.7225
R125 w_P006.n11 w_P006.n0 25.7667
R126 w_P006.n0 w_P006.n6 32.1173
R127 w_P006.n6 w_P006.n7 8.8
R128 w_P006.n7 w_P006.n8 8.8
R129 w_P006.n8 w_P006.n9 8.8
R130 w_P006.n9 w_P006.n10 8.8
R131 w_T0281 w_P006.n10 28.5225
R132 w_T0279 w_P006.n10 19.7225
R133 w_T0277 w_P006.n9 19.7225
R134 w_T0275 w_P006.n8 19.7225
R135 w_T0273 w_P006.n7 19.7225
R136 w_T0271 w_P006.n6 19.7225
R137 w_P006.n0 w_P006.n1 11.584
R138 w_P006.n1 w_P006.n2 8.8
R139 w_P006.n2 w_P006.n3 8.8
R140 w_P006.n3 w_P006.n4 8.8
R141 w_P006.n4 w_P006.n5 8.8
R142 w_T0269 w_P006.n5 27.0559
R143 w_T0267 w_P006.n5 18.2559
R144 w_T0265 w_P006.n4 18.2559
R145 w_T0263 w_P006.n3 18.2559
R146 w_T0261 w_P006.n2 18.2559
R147 w_T0259 w_P006.n1 18.2559
R148 w_T0240 w_T0240.n2 21.7307
R149 w_T0240.n2 w_T0240.n1 3.388
R150 w_T0202 w_T0240.n2 28.9839
R151 w_T0240.n1 w_T0197 23.3104
R152 w_T0240.n1 w_T0240.n0 72.7267
R153 w_T0240.n0 w_T0105 42.6535
R154 w_T0240.n0 w_T0081 25.0535
R155 w_T0242 w_T0242.n2 20.9973
R156 w_T0242.n2 w_T0242.n1 3.388
R157 w_T0205 w_T0242.n2 28.2505
R158 w_T0242.n1 w_T0200 22.577
R159 w_T0242.n1 w_T0242.n0 73.0787
R160 w_T0242.n0 w_T0109 45.4402
R161 w_T0242.n0 w_T0077 24.3202
R162 DIV_AVDD w_P003.n8 0.044
R163 w_P003.n8 w_P003.n0 0.44
R164 w_P003.n0 w_P003.n1 13.288
R165 w_P003.n1 w_P003.n2 1.76
R166 w_P003.n2 w_P003.n3 17.6
R167 w_P003.n3 w_P003.n4 1.76
R168 w_P003.n4 w_P003.n5 15.84
R169 w_P003.n5 w_P003.n6 1.76
R170 w_T0166 w_P003.n7 23.5054
R171 w_P003.n6 w_T0163 23.0505
R172 w_P003.n5 w_T0160 23.0505
R173 w_P003.n4 w_T0157 19.3248
R174 w_P003.n3 w_T0154 19.3248
R175 w_P003.n2 w_T0145 19.3248
R176 w_P003.n14 w_P003.n8 1.00058
R177 w_P003.n9 w_P003.n14 0.401282
R178 w_P003.n10 w_P003.n9 0.0743217
R179 w_P003.n11 w_P003.n10 0.734322
R180 w_P003.n12 w_P003.n11 0.0743217
R181 w_P003.n13 w_P003.n12 0.660988
R182 w_P003.n14 w_P003.n15 1.1451
R183 w_P003.n15 w_P003.n16 1.51658
R184 w_P003.n16 w_P003.n17 0.0743217
R185 w_P003.n17 w_P003.n18 0.734322
R186 w_P003.n18 w_P003.n19 0.142548
R187 w_P003.n20 w_P003.n21 1.76
R188 w_P003.n21 w_P003.n22 17.6
R189 w_P003.n22 w_P003.n23 1.76
R190 w_P003.n19 w_T0232 24.3484
R191 w_P003.n23 w_T0229 19.3248
R192 w_P003.n22 w_T0226 19.3248
R193 w_P003.n21 w_T0217 19.3248
R194 w_P003.n0 w_P003.n24 25.7667
R195 w_P003.n24 w_P003.n20 38.3213
R196 w_P003.n25 w_P003.n24 17.788
R197 w_P003.n25 w_P003.n26 8.8
R198 w_P003.n27 w_T0193 18.3133
R199 w_P003.n26 w_T0190 17.8581
R200 w_P003.n15 w_P003.n28 0.673422
R201 w_P003.n28 w_P003.n27 0.581796
R202 w_P003.n27 w_P003.n26 0.417726
R203 w_P003.n28 w_P003.n25 0.82689
R204 w_P003.n25 w_T0187 21.5839
R205 w_P003.n19 w_P003.n23 0.721999
R206 w_P003.n18 w_P003.n22 0.82689
R207 w_P003.n17 w_P003.n21 0.82689
R208 w_P003.n16 w_P003.n20 0.82689
R209 w_P003.n20 w_T0214 19.3248
R210 w_P003.n7 w_P003.n13 0.288287
R211 w_P003.n7 w_P003.n6 0.417845
R212 w_P003.n13 w_P003.n5 0.82689
R213 w_P003.n12 w_P003.n4 0.82689
R214 w_P003.n11 w_P003.n3 0.82689
R215 w_P003.n10 w_P003.n2 0.82689
R216 w_P003.n9 w_P003.n1 0.82689
R217 w_P003.n1 w_T0142 19.3248
R218 w_T0223.n0 w_T0223 9
R219 w_T0223 w_T0223.n1 41.3185
R220 w_T0223.n1 w_T0223.n2 5.544
R221 w_T0223.n2 w_T0126 27.0215
R222 w_T0223.n2 w_T0122 25.2615
R223 w_T0223.n1 w_T0108 29.18
R224 w_T0220.n0 w_T0220 9
R225 w_T0220 w_T0220.n1 40.5852
R226 w_T0220.n1 w_T0220.n2 3.784
R227 w_T0220.n2 w_T0118 26.2881
R228 w_T0220.n2 w_T0114 24.5281
R229 w_T0220.n1 w_T0104 28.4467
R230 w_T0110.n0 w_T0110 28.162
R231 w_T0106 w_T0110.n0 26.4018
R232 w_T0110.n0 w_T0100 31.9373
R233 w_T0211.n0 w_T0211 9
R234 w_T0211 w_T0211.n1 43.5185
R235 w_T0211.n1 w_T0211.n2 5.544
R236 w_T0211.n2 w_T0098 29.2215
R237 w_T0211.n2 w_T0094 27.4615
R238 w_T0211.n1 w_T0080 31.38
R239 w_T0208.n0 w_T0208 9
R240 w_T0208 w_T0208.n1 42.7852
R241 w_T0208.n1 w_T0208.n2 3.784
R242 w_T0208.n2 w_T0134 28.4881
R243 w_T0208.n2 w_T0090 26.7281
R244 w_T0208.n1 w_T0076 30.6467
R245 w_T0082.n0 w_T0082 30.362
R246 w_T0078 w_T0082.n0 28.6018
R247 w_T0082.n0 w_T0064 34.1373
R248 w_T0245 w_T0245.n0 40.5944
R249 w_T0245.n1 w_T0245.n0 7.172
R250 w_T0245.n2 w_T0245.n1 6.776
R251 w_T0245.n3 w_T0245.n2 1.892
R252 w_T0120 w_T0245.n3 28.201
R253 w_T0245.n3 w_T0117 26.1132
R254 w_T0245.n2 w_T0112 26.573
R255 w_T0245.n1 w_T0230 25.8682
R256 w_T0245.n0 w_T0097 26.1132
R257 w_T0243 w_T0243.n0 39.8603
R258 w_T0243.n1 w_T0243.n0 7.172
R259 w_T0243.n2 w_T0243.n1 8.668
R260 w_T0243.n3 w_T0243.n2 1.628
R261 w_T0124 w_T0243.n3 29.3597
R262 w_T0243.n3 w_T0116 25.8397
R263 w_T0243.n2 w_T0113 25.3799
R264 w_T0243.n1 w_T0227 25.1349
R265 w_T0243.n0 w_T0093 25.3799
R266 QP w_P005.n0 15.664
R267 w_P005.n1 w_P005.n0 6.776
R268 w_P005.n2 w_P005.n1 1.892
R269 w_P005.n3 w_P005.n2 1.628
R270 w_T0121 w_P005.n3 39.7385
R271 w_P005.n3 w_T0092 20.7063
R272 w_P005.n2 w_T0133 20.2465
R273 w_P005.n1 w_T0088 20.7063
R274 w_P005.n0 w_T0218 20.0016
R275 QN w_P004.n0 13.904
R276 w_P004.n1 w_P004.n0 8.668
R277 w_P004.n2 w_P004.n1 1.628
R278 w_P004.n3 w_P004.n2 3.52
R279 w_T0125 w_P004.n3 40.4719
R280 w_P004.n3 w_T0096 21.4397
R281 w_P004.n2 w_T0132 21.4397
R282 w_P004.n1 w_T0089 20.9799
R283 w_P004.n0 w_T0215 20.7349
R284 w_T0233.n0 w_T0233 9
R285 w_T0233 w_T0233.n3 31.4435
R286 w_T0233.n2 w_T0233.n1 12.188
R287 w_T0233.n3 w_T0233.n2 0.132
R288 w_T0233.n3 w_T0129 26.643
R289 w_T0233.n2 w_T0128 27.1307
R290 w_T0233.n1 w_T0101 27.2535
R291 w_T0233.n1 w_T0065 46.6135
R292 AVSS w_P000.n10 0.044
R293 w_P000.n10 w_P000.n0 0.616
R294 w_P000.n0 w_P000.n1 6.116
R295 w_P000.n1 w_P000.n2 1.76
R296 w_P000.n2 w_P000.n3 1.848
R297 w_P000.n3 w_P000.n4 1.76
R298 w_P000.n4 w_P000.n5 5.28
R299 w_P000.n5 w_P000.n6 12.32
R300 w_P000.n6 w_P000.n7 1.76
R301 w_P000.n7 w_P000.n8 5.28
R302 w_T0054 w_P000.n9 17.3329
R303 w_T0026 w_P000.n8 16.8024
R304 w_P000.n7 w_T0152 20.2668
R305 w_P000.n6 w_T0149 20.2668
R306 w_T0002 w_P000.n5 16.8024
R307 w_P000.n4 w_T0140 20.2668
R308 w_P000.n3 w_T0137 20.2668
R309 w_T0238 w_P000.n2 13.6294
R310 w_P000.n18 w_P000.n10 1.02992
R311 w_P000.n11 w_P000.n18 0.0804488
R312 w_P000.n12 w_P000.n11 0.0743217
R313 w_P000.n13 w_P000.n12 0.0779884
R314 w_P000.n14 w_P000.n13 0.0743217
R315 w_P000.n15 w_P000.n14 0.220988
R316 w_P000.n16 w_P000.n15 0.514322
R317 w_P000.n17 w_P000.n16 0.0743217
R318 w_P000.n18 w_P000.n19 1.1451
R319 w_P000.n19 w_P000.n20 1.19574
R320 w_P000.n20 w_P000.n21 0.0743217
R321 w_P000.n21 w_P000.n22 0.0779884
R322 w_P000.n22 w_P000.n23 0.0743217
R323 w_P000.n23 w_P000.n24 0.220988
R324 w_P000.n24 w_P000.n25 0.514322
R325 w_P000.n25 w_P000.n26 0.0743217
R326 w_P000.n26 w_P000.n27 0.297985
R327 w_P000.n28 w_P000.n29 1.76
R328 w_P000.n29 w_P000.n30 1.848
R329 w_P000.n30 w_P000.n31 1.76
R330 w_P000.n31 w_P000.n32 5.28
R331 w_P000.n32 w_P000.n33 12.32
R332 w_P000.n33 w_P000.n34 1.76
R333 w_P000.n34 w_P000.n35 5.28
R334 w_P000.n27 w_T0130 17.3325
R335 w_P000.n35 w_T0102 16.8018
R336 w_P000.n34 w_T0224 20.2668
R337 w_P000.n33 w_T0221 20.2668
R338 w_P000.n32 w_T0066 16.8018
R339 w_P000.n31 w_T0212 20.2668
R340 w_P000.n30 w_T0209 20.2668
R341 w_T0246 w_P000.n29 13.6294
R342 w_P000.n0 w_P000.n36 25.7667
R343 w_P000.n36 w_P000.n28 31.1493
R344 w_P000.n37 w_P000.n36 14.224
R345 w_P000.n37 w_P000.n38 1.76
R346 w_P000.n38 w_P000.n39 3.52
R347 w_P000.n39 w_P000.n40 5.28
R348 w_P000.n40 w_P000.n41 8.8
R349 w_P000.n42 w_T0206 21.558
R350 w_P000.n41 w_T0203 21.1028
R351 w_T0086 w_P000.n40 15.3357
R352 w_T0062 w_P000.n39 14.726
R353 w_P000.n38 w_T0185 20.4428
R354 w_P000.n19 w_P000.n43 0.502922
R355 w_P000.n43 w_P000.n44 0.0743217
R356 w_P000.n44 w_P000.n45 0.147655
R357 w_P000.n45 w_P000.n46 0.220988
R358 w_P000.n46 w_P000.n42 0.581796
R359 w_P000.n42 w_P000.n41 0.417726
R360 w_P000.n46 w_P000.n40 0.82689
R361 w_P000.n45 w_P000.n39 0.82689
R362 w_P000.n44 w_P000.n38 0.82689
R363 w_P000.n43 w_P000.n37 0.82689
R364 w_P000.n37 w_T0182 20.4428
R365 w_P000.n27 w_P000.n35 0.703697
R366 w_P000.n26 w_P000.n34 0.82689
R367 w_P000.n25 w_P000.n33 0.82689
R368 w_P000.n24 w_P000.n32 0.82689
R369 w_P000.n23 w_P000.n31 0.82689
R370 w_P000.n22 w_P000.n30 0.82689
R371 w_P000.n21 w_P000.n29 0.82689
R372 w_P000.n20 w_P000.n28 0.82689
R373 w_T0244 w_P000.n28 13.6267
R374 w_P000.n9 w_P000.n17 0.297985
R375 w_P000.n9 w_P000.n8 0.703697
R376 w_P000.n17 w_P000.n7 0.82689
R377 w_P000.n16 w_P000.n6 0.82689
R378 w_P000.n15 w_P000.n5 0.82689
R379 w_P000.n14 w_P000.n4 0.82689
R380 w_P000.n13 w_P000.n3 0.82689
R381 w_P000.n12 w_P000.n2 0.82689
R382 w_P000.n11 w_P000.n1 0.82689
R383 w_T0236 w_P000.n1 13.6267
C0 w_T0239 w_T0188 4.1509899902343754e-16
C1 DIV_AVDD w_T0242 2.5591398925781249e-15
C2 w_T0235 w_T0139 7.0416499023437511e-15
C3 AVSS w_T0010 2.8226999511718753e-15
C4 SUB w_T0136 1.6763699951171877e-15
C5 w_T0175 w_T0136 7.2224101562499995e-15
C6 w_T0235 AVSS 5.6788300781250007e-15
C7 w_T0240 w_T0208 1.7210500488281253e-15
C8 w_T0237 w_T0173 2.0882099609375005e-15
C9 w_T0239 w_T0084 2.2613300781249999e-15
C10 w_T0208 DIV_AVDD 2.045180053710938e-15
C11 w_T0184 w_T0178 2.7696799316406253e-15
C12 SUB w_T0211 1.6763699951171877e-15
C13 SUB w_T0184 1.245300048828125e-15
C14 w_T0240 DIV_AVDD 2.5807099609375001e-15
C15 w_T0173 w_T0139 5.2242900390624999e-15
C16 QP w_T0233 7.9823901367187507e-16
C17 SUB w_T0110 1.245300048828125e-15
C18 QP QN 5.9281699218750004e-15
C19 w_T0173 AVSS 9.274520263671876e-16
C20 SUB w_T0220 1.6763699951171877e-15
C21 w_T0243 w_T0211 6.4897001953125006e-15
C22 w_T0151 DIV_AVDD 1.9967600097656252e-15
C23 w_T0148 w_T0178 1.6763699951171877e-15
C24 w_T0243 w_T0110 1.2707399902343751e-15
C25 w_T0243 w_T0220 7.3911098632812507e-15
C26 SUB w_T0148 1.6763699951171877e-15
C27 w_T0175 w_T0148 1.6763699951171877e-15
C28 w_T0161 w_T0178 8.3019799804687509e-16
C29 QP w_T0082 1.245300048828125e-15
C30 w_T0034 w_T0148 3.0199499511718755e-15
C31 w_T0211 w_T0242 1.6763699951171877e-15
C32 AVSS w_T0233 1.47057998046875e-14
C33 SUB w_T0161 2.0914699707031252e-15
C34 w_T0175 w_T0161 8.3019799804687509e-16
C35 QN AVSS 4.8958398437500005e-15
C36 w_T0242 w_T0110 5.5305000000000002e-15
C37 w_T0034 w_T0161 6.4731899414062509e-15
C38 w_T0242 w_T0220 8.4617700195312506e-16
C39 w_T0233 w_T0223 1.7210500488281253e-15
C40 w_T0136 DIV_AVDD 1.9967600097656252e-15
C41 QN w_T0223 4.4248300781250004e-15
C42 w_T0211 w_T0208 8.5889599609375007e-16
C43 w_T0237 w_T0178 6.0088500976562507e-15
C44 AVSS w_T0082 2.8240300292968755e-15
C45 SUB QP 2.5686298828125003e-15
C46 w_T0237 SUB 2.4905900878906251e-15
C47 w_T0237 w_T0175 6.2973500976562505e-15
C48 w_T0170 w_T0010 6.063220214843751e-15
C49 w_T0240 w_T0211 5.5017998046875003e-15
C50 w_T0170 w_T0235 2.0882099609375005e-15
C51 w_T0243 QP 4.1931298828125009e-15
C52 w_T0211 DIV_AVDD 1.9817499999999999e-15
C53 w_T0237 w_T0034 1.2707399902343751e-15
C54 w_T0240 w_T0110 5.3905498046874999e-15
C55 w_T0184 DIV_AVDD 1.4658599853515627e-15
C56 w_T0139 w_T0178 2.5780800781250006e-15
C57 w_T0240 w_T0220 4.6702900390625007e-15
C58 DIV_AVDD w_T0110 1.4863100585937502e-15
C59 AVSS w_T0178 5.7418598632812502e-15
C60 DIV_AVDD w_T0220 1.9817499999999999e-15
C61 SUB w_T0139 1.6763699951171877e-15
C62 w_T0175 w_T0139 2.5780800781250006e-15
C63 SUB AVSS 3.4101300781250007e-14
C64 w_T0175 AVSS 5.7418598632812502e-15
C65 QP w_T0242 1.2114799804687499e-15
C66 w_T0148 DIV_AVDD 1.9967600097656252e-15
C67 w_T0034 AVSS 2.8226999511718753e-15
C68 w_T0173 w_T0170 1.2293199462890627e-15
C69 w_T0151 w_T0148 8.5889599609375007e-16
C70 w_T0243 AVSS 5.7319199218750004e-15
C71 SUB w_T0223 1.7018100585937501e-15
C72 w_T0245 w_T0233 8.3019799804687509e-16
C73 QN w_T0245 4.8960898437499997e-15
C74 DIV_AVDD w_T0161 4.6263398437500004e-15
C75 QP w_T0208 5.4363999023437505e-15
C76 w_T0243 w_T0223 2.8127700195312503e-15
C77 w_T0151 w_T0161 1.7210500488281253e-15
C78 w_T0170 CLKN 2.6387600097656254e-15
C79 SUB w_T0241 1.6834399414062501e-15
C80 w_T0181 w_T0178 4.3107800292968757e-16
C81 w_T0245 w_T0082 1.2707399902343751e-15
C82 AVSS w_T0242 5.6883901367187505e-15
C83 QP w_T0240 1.2204000244140626e-15
C84 QP DIV_AVDD 5.3793901367187504e-15
C85 w_T0181 SUB 1.245300048828125e-15
C86 w_T0181 w_T0175 3.0448200683593752e-15
C87 w_T0237 DIV_AVDD 5.7202797851562504e-15
C88 w_T0242 w_T0223 4.3951499023437504e-15
C89 w_T0237 w_T0151 2.1775900878906249e-15
C90 AVSS w_T0208 3.8304099121093753e-15
C91 SUB w_T0188 1.6763699951171877e-15
C92 w_T0136 w_T0161 1.2899699707031251e-15
C93 w_T0242 w_T0241 2.5211300781250001e-14
C94 w_T0220 w_T0110 3.0212800292968753e-15
C95 w_T0240 AVSS 5.7143398437500007e-15
C96 DIV_AVDD w_T0139 1.9967600097656252e-15
C97 SUB w_T0084 1.245300048828125e-15
C98 SUB w_T0245 2.5192900390625003e-15
C99 AVSS DIV_AVDD 1.4598200000000002e-13
C100 w_T0151 AVSS 3.7669899902343754e-15
C101 w_T0240 w_T0223 4.3107800292968757e-16
C102 w_T0243 w_T0245 1.0655099609375e-14
C103 w_T0170 w_T0178 7.9823901367187507e-16
C104 w_T0235 w_T0010 1.2707399902343751e-15
C105 DIV_AVDD w_T0223 2.0282700195312503e-15
C106 w_T0237 w_T0136 1.7210500488281253e-15
C107 w_T0170 SUB 7.9823901367187507e-16
C108 w_T0188 w_T0242 1.6763699951171877e-15
C109 w_T0240 w_T0241 1.2899699707031251e-15
C110 w_T0170 w_T0175 7.9823901367187507e-16
C111 DIV_AVDD w_T0241 2.5779099121093755e-15
C112 w_T0170 w_T0034 6.4796401367187501e-15
C113 w_T0242 w_T0084 1.2707399902343751e-15
C114 w_T0245 w_T0242 1.2772600097656251e-15
C115 QP w_T0211 2.5631101074218751e-15
C116 w_T0136 w_T0139 8.5889599609375007e-16
C117 w_T0148 w_T0161 1.7210500488281253e-15
C118 w_T0136 AVSS 3.7669899902343754e-15
C119 QP w_T0110 1.245300048828125e-15
C120 w_T0173 w_T0010 5.9232597656250003e-15
C121 QP w_T0220 1.6604000244140626e-15
C122 w_T0181 DIV_AVDD 1.4658599853515627e-15
C123 w_T0245 w_T0208 1.7210500488281253e-15
C124 w_T0173 w_T0235 2.0882099609375005e-15
C125 w_T0240 w_T0188 1.6763699951171877e-15
C126 w_T0188 DIV_AVDD 3.7020600585937506e-15
C127 w_T0240 w_T0084 1.2707399902343751e-15
C128 w_T0237 w_T0148 8.3357099609375012e-15
C129 w_T0240 w_T0245 1.2772600097656251e-15
C130 AVSS w_T0211 3.7669899902343754e-15
C131 SUB w_T0239 1.8576600341796875e-15
C132 w_T0184 AVSS 3.3058701171875e-15
C133 DIV_AVDD w_T0084 1.4975699462890626e-15
C134 w_T0245 DIV_AVDD 5.7508598632812509e-15
C135 AVSS w_T0110 2.8240300292968755e-15
C136 w_T0237 w_T0161 8.3019799804687509e-16
C137 AVSS w_T0220 3.7669899902343754e-15
C138 w_T0223 w_T0110 3.23089990234375e-15
C139 w_T0220 w_T0223 8.5889599609375007e-16
C140 w_T0148 AVSS 3.7669899902343754e-15
C141 w_T0184 w_T0241 4.1509899902343754e-16
C142 w_T0170 DIV_AVDD 3.9466499023437503e-15
C143 w_T0173 CLKN 4.3107800292968757e-16
C144 w_T0170 w_T0151 5.8023901367187504e-15
C145 w_T0139 w_T0161 1.2899699707031251e-15
C146 w_T0239 w_T0242 1.6961600341796875e-15
C147 AVSS w_T0161 1.4710400390625002e-14
C148 w_T0181 w_T0184 8.3019799804687509e-16
C149 w_T0010 w_T0178 1.245300048828125e-15
C150 w_T0235 w_T0178 6.0062202148437503e-15
C151 w_T0184 w_T0188 1.2612800292968751e-15
C152 w_T0237 w_T0139 7.3327700195312512e-15
C153 SUB w_T0010 1.245300048828125e-15
C154 w_T0175 w_T0010 1.245300048828125e-15
C155 QP AVSS 4.8958398437500005e-15
C156 w_T0237 AVSS 5.6967299804687504e-15
C157 SUB w_T0235 2.4905900878906251e-15
C158 w_T0235 w_T0175 5.8688901367187502e-15
C159 w_T0170 w_T0136 4.9811098632812506e-15
C160 w_T0239 w_T0240 2.5663300781250004e-14
C161 w_T0245 w_T0211 6.7808300781250001e-15
C162 QN w_T0233 7.9823901367187507e-16
C163 w_T0184 w_T0084 4.1338598632812509e-15
C164 QP w_T0223 3.7218701171875001e-15
C165 w_T0239 DIV_AVDD 3.0281000976562501e-15
C166 w_T0034 w_T0235 1.2707399902343751e-15
C167 w_T0245 w_T0110 1.2707399902343751e-15
C168 w_T0245 w_T0220 7.7847597656250002e-15
C169 w_T0173 CLKP 2.3636201171875006e-15
C170 AVSS w_T0139 3.7669899902343754e-15
C171 w_T0173 w_T0178 7.9823901367187507e-16
C172 w_T0082 w_T0233 5.5261801757812501e-15
C173 QN w_T0082 1.245300048828125e-15
C174 w_T0173 SUB 7.9823901367187507e-16
C175 w_T0173 w_T0175 7.9823901367187507e-16
C176 AVSS w_T0223 3.8097500000000008e-15
C177 w_T0173 w_T0034 6.7675000000000004e-15
C178 w_T0170 w_T0148 1.6763699951171877e-15
C179 AVSS w_T0241 1.5346600341796876e-15
C180 SUB w_T0233 2.0914699707031252e-15
C181 SUB QN 2.5686298828125003e-15
C182 w_T0170 w_T0161 1.6763699951171877e-15
C183 QP w_T0245 4.6056098632812507e-15
C184 DIV_AVDD w_T0010 1.4975699462890626e-15
C185 w_T0243 w_T0233 8.3019799804687509e-16
C186 w_T0243 QN 4.8967299804687508e-15
C187 w_T0181 AVSS 3.3058701171875e-15
C188 w_T0235 DIV_AVDD 5.7202797851562504e-15
C189 w_T0239 w_T0184 3.38043994140625e-15
C190 w_T0235 w_T0151 2.6054099121093753e-15
C191 SUB w_T0082 1.245300048828125e-15
C192 w_T0188 AVSS 9.4647001953124995e-15
C193 w_T0237 w_T0170 2.0882099609375005e-15
C194 w_T0243 w_T0082 1.2707399902343751e-15
C195 w_T0233 w_T0242 8.3019799804687509e-16
C196 AVSS w_T0084 2.8226999511718753e-15
C197 QN w_T0242 1.2114799804687499e-15
C198 w_T0181 w_T0241 3.6555900878906253e-15
C199 w_T0245 AVSS 5.7498198242187501e-15
C200 SUB w_T0178 2.8967700195312501e-15
C201 w_T0173 DIV_AVDD 3.4881398925781252e-15
C202 w_T0175 w_T0178 1.6336500000000002e-14
C203 w_T0245 w_T0223 2.59131005859375e-15
C204 w_T0136 w_T0010 3.4326699218750003e-15
C205 w_T0188 w_T0241 4.1509899902343754e-16
C206 w_T0173 w_T0151 1.7145300292968751e-15
C207 w_T0208 w_T0233 1.2899699707031251e-15
C208 QN w_T0208 5.8300498046875e-15
C209 w_T0170 w_T0139 1.245300048828125e-15
C210 w_T0235 w_T0136 1.7210500488281253e-15
C211 SUB w_T0175 2.8967700195312501e-15
C212 w_T0034 w_T0178 1.245300048828125e-15
C213 w_T0082 w_T0242 5.9272299804687505e-15
C214 w_T0170 AVSS 9.274520263671876e-16
C215 w_T0084 w_T0241 2.4827900390625002e-15
C216 w_T0034 SUB 1.245300048828125e-15
C217 w_T0034 w_T0175 1.245300048828125e-15
C218 w_T0243 SUB 2.5192900390625003e-15
C219 w_T0240 w_T0233 8.3019799804687509e-16
C220 w_T0181 w_T0188 1.2612800292968751e-15
C221 QN w_T0240 1.2204000244140626e-15
C222 w_T0233 DIV_AVDD 4.1603300781250002e-15
C223 w_T0208 w_T0082 3.4340000000000006e-15
C224 QN DIV_AVDD 1.0607000000000001e-14
C225 w_T0181 w_T0084 3.9939099121093757e-15
C226 w_T0242 w_T0178 9.2669500732421888e-16
C227 w_T0173 w_T0136 8.6215600585937513e-16
C228 w_T0240 w_T0082 6.2150898437500008e-15
C229 SUB w_T0242 6.9226801757812506e-15
C230 w_T0175 w_T0242 8.5323901367187508e-16
C231 w_T0188 w_T0084 5.9267998046874999e-15
C232 w_T0082 DIV_AVDD 1.4863100585937502e-15
C233 w_T0243 w_T0242 1.2772600097656251e-15
C234 w_T0235 w_T0148 7.94206005859375e-15
C235 w_T0239 AVSS 1.5263399658203127e-15
C236 SUB w_T0208 1.7083299560546876e-15
C237 w_T0161 w_T0010 6.076470214843751e-15
C238 w_T0240 w_T0178 1.7492600097656252e-15
C239 w_T0235 w_T0161 8.3019799804687509e-16
C240 w_T0243 w_T0208 1.7210500488281253e-15
C241 DIV_AVDD w_T0178 8.5148398437500011e-15
C242 SUB w_T0240 4.2528598632812506e-15
C243 w_T0175 w_T0240 9.279229736328125e-16
C244 w_T0151 w_T0178 5.5303300781250008e-15
C245 SUB DIV_AVDD 1.0603299804687501e-14
C246 w_T0175 DIV_AVDD 8.5148398437500011e-15
C247 w_T0239 w_T0241 1.7210500488281253e-15
C248 SUB w_T0151 1.6763699951171877e-15
C249 w_T0175 w_T0151 5.3903701171875003e-15
C250 w_T0243 w_T0240 1.2772600097656251e-15
C251 w_T0173 w_T0148 6.0520898437500003e-15
C252 w_T0211 w_T0233 1.2899699707031251e-15
C253 w_T0034 DIV_AVDD 1.4975699462890626e-15
C254 QN w_T0211 2.5631101074218751e-15
C255 w_T0237 w_T0010 1.2707399902343751e-15
C256 w_T0243 DIV_AVDD 5.7508598632812509e-15
C257 w_T0034 w_T0151 3.2295700683593749e-15
C258 w_T0208 w_T0242 5.2586201171875005e-15
C259 w_T0237 w_T0235 1.1755599609375002e-14
C260 w_T0233 w_T0110 5.9228999023437508e-15
C261 QN w_T0110 1.245300048828125e-15
C262 w_T0173 w_T0161 1.6763699951171877e-15
C263 w_T0233 w_T0220 1.7210500488281253e-15
C264 QN w_T0220 1.6604000244140626e-15
C265 w_T0240 w_T0242 6.9312500000000008e-15
C266 w_T0136 w_T0178 6.8287597656250005e-15
C267 w_T0211 w_T0082 3.4372600097656252e-15
C268 w_T0139 w_T0010 3.435929931640625e-15
C269 CLKP WIRE_CREF 1.4489422851562501e-14
C270 w_T0172 WIRE_CREF 4.2531767578124998e-15
C271 CLKN WIRE_CREF 1.6650033203125001e-14
C272 w_T0169 WIRE_CREF 5.2685668945312503e-15
C273 w_T0151 WIRE_CREF 6.5011938476562504e-15
C274 w_T0050 WIRE_CREF 5.2276640624999999e-15
C275 w_T0046 WIRE_CREF 4.7797749023437498e-15
C276 w_T0032 WIRE_CREF 4.1043647460937504e-15
C277 w_T0148 WIRE_CREF 6.1906499023437497e-15
C278 w_T0042 WIRE_CREF 4.91055126953125e-15
C279 w_T0038 WIRE_CREF 4.4742690429687504e-15
C280 w_T0028 WIRE_CREF 3.8259145507812506e-15
C281 w_T0034 WIRE_CREF 5.7993457031250005e-15
C282 w_T0030 WIRE_CREF 5.3452426757812511e-15
C283 w_T0024 WIRE_CREF 4.8695761718750005e-15
C284 w_T0139 WIRE_CREF 7.2547285156250008e-15
C285 w_T0058 WIRE_CREF 6.0390097656250006e-15
C286 w_T0022 WIRE_CREF 5.5715639648437505e-15
C287 w_T0008 WIRE_CREF 4.8387822265624997e-15
C288 w_T0136 WIRE_CREF 7.1964106445312498e-15
C289 w_T0018 WIRE_CREF 5.9272919921875e-15
C290 w_T0014 WIRE_CREF 5.4532436523437503e-15
C291 w_T0004 WIRE_CREF 4.7190981445312502e-15
C292 w_T0010 WIRE_CREF 6.6310927734374998e-15
C293 w_T0006 WIRE_CREF 6.1571010742187504e-15
C294 w_T0000 WIRE_CREF 5.6481523437499999e-15
C295 w_T0237 WIRE_CREF 1.3798926757812502e-14
C296 w_T0158 WIRE_CREF 3.0346428222656253e-15
C297 w_T0057 WIRE_CREF 3.0550458984375006e-15
C298 w_T0044 WIRE_CREF 3.3268466796875001e-15
C299 w_T0041 WIRE_CREF 3.0550458984375006e-15
C300 w_T0036 WIRE_CREF 2.9984873046875003e-15
C301 w_T0235 WIRE_CREF 1.3451114257812502e-14
C302 w_T0155 WIRE_CREF 2.8051372070312503e-15
C303 w_T0048 WIRE_CREF 3.5930324707031254e-15
C304 w_T0040 WIRE_CREF 2.7716899414062502e-15
C305 w_T0037 WIRE_CREF 2.8246970214843756e-15
C306 w_T0021 WIRE_CREF 2.8246970214843756e-15
C307 w_T0173 WIRE_CREF 3.2938388671875003e-15
C308 w_T0167 WIRE_CREF 2.0780947265625001e-15
C309 w_T0029 WIRE_CREF 2.57283154296875e-15
C310 w_T0009 WIRE_CREF 9.6933066406250006e-15
C311 w_T0170 WIRE_CREF 3.0795576171875002e-15
C312 w_T0164 WIRE_CREF 1.8995711669921878e-15
C313 w_T0033 WIRE_CREF 2.37522802734375e-15
C314 w_T0005 WIRE_CREF 1.1478158203125001e-14
C315 w_T0161 WIRE_CREF 2.8090834960937502e-15
C316 w_T0053 WIRE_CREF 3.141075927734375e-15
C317 w_T0052 WIRE_CREF 3.060698974609375e-15
C318 w_T0025 WIRE_CREF 3.1541770019531254e-15
C319 w_T0001 WIRE_CREF 1.1277485351562502e-14
C320 w_T0178 WIRE_CREF 2.0862898437500003e-14
C321 w_T0143 WIRE_CREF 2.0695588378906252e-15
C322 w_T0056 WIRE_CREF 2.0458255615234375e-15
C323 w_T0049 WIRE_CREF 1.0686355468750001e-14
C324 w_T0016 WIRE_CREF 2.0458255615234375e-15
C325 w_T0013 WIRE_CREF 2.0863554687500001e-15
C326 w_T0175 WIRE_CREF 2.0224134765624999e-14
C327 w_T0146 WIRE_CREF 2.2833256835937501e-15
C328 w_T0045 WIRE_CREF 1.0991045898437502e-14
C329 w_T0020 WIRE_CREF 2.256646484375e-15
C330 w_T0017 WIRE_CREF 2.3011562500000004e-15
C331 w_T0012 WIRE_CREF 2.256646484375e-15
C332 w_T0084 WIRE_CREF 3.8575341796875001e-15
C333 w_T0074 WIRE_CREF 4.1487426757812499e-15
C334 w_T0070 WIRE_CREF 4.5890844726562501e-15
C335 w_T0184 WIRE_CREF 1.3917624511718751e-15
C336 w_T0179 WIRE_CREF 2.3946687011718751e-15
C337 w_T0073 WIRE_CREF 3.7999145507812506e-15
C338 w_T0181 WIRE_CREF 1.5604610595703127e-15
C339 w_T0176 WIRE_CREF 2.6065107421875003e-15
C340 w_T0069 WIRE_CREF 4.0169738769531253e-15
C341 w_T0241 WIRE_CREF 1.7450945312500001e-14
C342 w_T0199 WIRE_CREF 2.2760517578125002e-15
C343 w_T0194 WIRE_CREF 2.2503674316406252e-15
C344 w_T0068 WIRE_CREF 4.2883618164062509e-15
C345 w_T0239 WIRE_CREF 1.7840611328125002e-14
C346 w_T0196 WIRE_CREF 2.4778920898437501e-15
C347 w_T0191 WIRE_CREF 2.4511350097656254e-15
C348 w_T0072 WIRE_CREF 3.3111833496093751e-15
C349 w_T0188 WIRE_CREF 2.615927001953125e-15
C350 w_T0085 WIRE_CREF 4.4674770507812503e-15
C351 w_T0061 WIRE_CREF 2.9693769531250002e-15
C352 w_T0060 WIRE_CREF 2.8890253906250003e-15
C353 SUB WIRE_CREF 8.4673229980468754e-16
C354 w_T0281 WIRE_CREF 6.4512353515625003e-15
C355 w_T0279 WIRE_CREF 2.9278557128906252e-15
C356 w_T0277 WIRE_CREF 2.9278557128906252e-15
C357 w_T0275 WIRE_CREF 2.9278557128906252e-15
C358 w_T0273 WIRE_CREF 2.9278557128906252e-15
C359 w_T0271 WIRE_CREF 2.9278557128906252e-15
C360 w_T0269 WIRE_CREF 6.0157465820312504e-15
C361 w_T0267 WIRE_CREF 2.4658439941406251e-15
C362 w_T0265 WIRE_CREF 2.4658439941406251e-15
C363 w_T0263 WIRE_CREF 2.4658439941406251e-15
C364 w_T0261 WIRE_CREF 2.4658439941406251e-15
C365 w_T0259 WIRE_CREF 2.4658439941406251e-15
C366 w_T0257 WIRE_CREF 6.4512353515625003e-15
C367 w_T0255 WIRE_CREF 2.9278557128906252e-15
C368 w_T0253 WIRE_CREF 2.9278557128906252e-15
C369 w_T0251 WIRE_CREF 2.9278557128906252e-15
C370 w_T0249 WIRE_CREF 2.9278557128906252e-15
C371 w_T0247 WIRE_CREF 2.9278557128906252e-15
C372 w_T0240 WIRE_CREF 1.7928773437500001e-14
C373 w_T0202 WIRE_CREF 1.7039560546875002e-15
C374 w_T0197 WIRE_CREF 1.9163151855468751e-15
C375 w_T0105 WIRE_CREF 8.8170878906250013e-15
C376 w_T0081 WIRE_CREF 2.08318017578125e-15
C377 w_T0242 WIRE_CREF 1.7252736328125001e-14
C378 w_T0205 WIRE_CREF 1.5143443603515626e-15
C379 w_T0200 WIRE_CREF 1.7022342529296875e-15
C380 w_T0109 WIRE_CREF 1.0321395507812501e-14
C381 w_T0077 WIRE_CREF 1.8672202148437503e-15
C382 DIV_AVDD WIRE_CREF 5.2078125000000005e-17
C383 w_T0232 WIRE_CREF 1.3018992919921876e-15
C384 w_T0229 WIRE_CREF 5.7380181884765629e-16
C385 w_T0226 WIRE_CREF 5.7380181884765629e-16
C386 w_T0217 WIRE_CREF 5.7380181884765629e-16
C387 w_T0214 WIRE_CREF 5.7380181884765629e-16
C388 w_T0193 WIRE_CREF 4.9204745483398446e-16
C389 w_T0190 WIRE_CREF 4.3785601806640628e-16
C390 w_T0187 WIRE_CREF 3.1160568237304688e-16
C391 w_T0166 WIRE_CREF 4.7811026000976565e-16
C392 w_T0163 WIRE_CREF 4.2907080078125002e-16
C393 w_T0160 WIRE_CREF 4.2907080078125002e-16
C394 w_T0157 WIRE_CREF 5.7380181884765629e-16
C395 w_T0154 WIRE_CREF 5.7380181884765629e-16
C396 w_T0145 WIRE_CREF 5.7380181884765629e-16
C397 w_T0142 WIRE_CREF 5.7380181884765629e-16
C398 w_T0223 WIRE_CREF 6.1045488281250003e-15
C399 w_T0126 WIRE_CREF 4.770546875e-15
C400 w_T0122 WIRE_CREF 4.3304028320312504e-15
C401 w_T0108 WIRE_CREF 3.6865266113281256e-15
C402 w_T0220 WIRE_CREF 5.7563632812500003e-15
C403 w_T0118 WIRE_CREF 4.4255405273437503e-15
C404 w_T0114 WIRE_CREF 4.0008854980468753e-15
C405 w_T0104 WIRE_CREF 3.3899799804687501e-15
C406 w_T0110 WIRE_CREF 5.3563188476562505e-15
C407 w_T0106 WIRE_CREF 4.9085249023437502e-15
C408 w_T0100 WIRE_CREF 4.4476923828125004e-15
C409 w_T0211 WIRE_CREF 6.8097119140625008e-15
C410 w_T0098 WIRE_CREF 5.5445756835937504e-15
C411 w_T0094 WIRE_CREF 5.085878417968751e-15
C412 w_T0080 WIRE_CREF 4.3846875000000003e-15
C413 w_T0208 WIRE_CREF 6.8867089843750001e-15
C414 w_T0134 WIRE_CREF 5.5375781249999999e-15
C415 w_T0090 WIRE_CREF 5.06313037109375e-15
C416 w_T0076 WIRE_CREF 4.3477499999999997e-15
C417 w_T0082 WIRE_CREF 6.1850463867187509e-15
C418 w_T0078 WIRE_CREF 5.7156958007812509e-15
C419 w_T0064 WIRE_CREF 5.2198974609375004e-15
C420 w_T0245 WIRE_CREF 1.3562120117187502e-14
C421 w_T0230 WIRE_CREF 2.6680324707031252e-15
C422 w_T0120 WIRE_CREF 2.9548261718750003e-15
C423 w_T0117 WIRE_CREF 2.6873408203125004e-15
C424 w_T0112 WIRE_CREF 2.63629345703125e-15
C425 w_T0097 WIRE_CREF 2.6873408203125004e-15
C426 w_T0243 WIRE_CREF 1.32520107421875e-14
C427 w_T0227 WIRE_CREF 2.4513732910156253e-15
C428 w_T0124 WIRE_CREF 3.2318847656250002e-15
C429 w_T0116 WIRE_CREF 2.4223962402343753e-15
C430 w_T0113 WIRE_CREF 2.4697978515625e-15
C431 w_T0093 WIRE_CREF 2.4697978515625e-15
C432 QP WIRE_CREF 1.21977412109375e-14
C433 w_T0218 WIRE_CREF 1.14656396484375e-15
C434 w_T0133 WIRE_CREF 1.1576654052734375e-15
C435 w_T0121 WIRE_CREF 9.540835937500001e-15
C436 w_T0092 WIRE_CREF 1.1375706787109375e-15
C437 w_T0088 WIRE_CREF 1.1375706787109375e-15
C438 QN WIRE_CREF 1.08622568359375e-14
C439 w_T0215 WIRE_CREF 1.3106568603515626e-15
C440 w_T0132 WIRE_CREF 1.2986997070312502e-15
C441 w_T0125 WIRE_CREF 9.694266601562501e-15
C442 w_T0096 WIRE_CREF 1.2986997070312502e-15
C443 w_T0089 WIRE_CREF 1.3229808349609377e-15
C444 w_T0233 WIRE_CREF 2.4352893066406251e-15
C445 w_T0129 WIRE_CREF 2.7421596679687503e-15
C446 w_T0128 WIRE_CREF 2.6679565429687505e-15
C447 w_T0101 WIRE_CREF 2.7595532226562499e-15
C448 w_T0065 WIRE_CREF 1.08656240234375e-14
C449 AVSS WIRE_CREF 5.1982551574707036e-17
C450 w_T0246 WIRE_CREF 1.0690021972656251e-15
C451 w_T0244 WIRE_CREF 1.0581087646484376e-15
C452 w_T0238 WIRE_CREF 1.0690021972656251e-15
C453 w_T0236 WIRE_CREF 1.0581087646484376e-15
C454 w_T0224 WIRE_CREF 2.5902844238281252e-16
C455 w_T0221 WIRE_CREF 2.5902844238281252e-16
C456 w_T0212 WIRE_CREF 2.5902844238281252e-16
C457 w_T0209 WIRE_CREF 2.5902844238281252e-16
C458 w_T0206 WIRE_CREF 3.6984417724609378e-16
C459 w_T0203 WIRE_CREF 3.2234301757812501e-16
C460 w_T0185 WIRE_CREF 2.7198260498046875e-16
C461 w_T0182 WIRE_CREF 2.7198260498046875e-16
C462 w_T0152 WIRE_CREF 2.5902844238281252e-16
C463 w_T0149 WIRE_CREF 2.5902844238281252e-16
C464 w_T0140 WIRE_CREF 2.5902844238281252e-16
C465 w_T0137 WIRE_CREF 2.5902844238281252e-16
C466 w_T0130 WIRE_CREF 1.5557818603515626e-15
C467 w_T0102 WIRE_CREF 9.5608410644531249e-16
C468 w_T0086 WIRE_CREF 7.9671813964843763e-16
C469 w_T0066 WIRE_CREF 9.5608410644531249e-16
C470 w_T0062 WIRE_CREF 5.9545440673828127e-16
C471 w_T0054 WIRE_CREF 1.5558105468750001e-15
C472 w_T0026 WIRE_CREF 9.5611346435546873e-16
C473 w_T0002 WIRE_CREF 9.5611346435546873e-16
C474 w_P000.n0 WIRE_CREF 5.1429799804687504e-15
C475 w_P000.n1 WIRE_CREF 4.4819672851562499e-15
C476 w_P000.n2 WIRE_CREF 2.8013942871093754e-15
C477 w_P000.n3 WIRE_CREF 2.5696306152343751e-15
C478 w_P000.n4 WIRE_CREF 3.9211767578124999e-15
C479 w_P000.n5 WIRE_CREF 8.4746718750000013e-15
C480 w_P000.n6 WIRE_CREF 6.6935795898437498e-15
C481 w_P000.n7 WIRE_CREF 3.9211767578124999e-15
C482 w_P000.n8 WIRE_CREF 8.4746718750000013e-15
C483 w_P000.n9 WIRE_CREF 3.3675031250000005e-14
C484 w_P000.n10 WIRE_CREF 1.5498896484375001e-15
C485 w_P000.n11 WIRE_CREF 4.5042514648437506e-15
C486 w_P000.n12 WIRE_CREF 4.4348222656250004e-15
C487 w_P000.n13 WIRE_CREF 4.4348222656250004e-15
C488 w_P000.n14 WIRE_CREF 8.4894628906249995e-15
C489 w_P000.n15 WIRE_CREF 2.0965271484375001e-14
C490 w_P000.n16 WIRE_CREF 1.6806667968750001e-14
C491 w_P000.n17 WIRE_CREF 1.62782109375e-14
C492 w_P000.n18 WIRE_CREF 2.4556554687500004e-14
C493 w_P000.n19 WIRE_CREF 4.6081156250000003e-14
C494 w_P000.n20 WIRE_CREF 2.6461589843750004e-14
C495 w_P000.n21 WIRE_CREF 4.4348222656250004e-15
C496 w_P000.n22 WIRE_CREF 4.4348222656250004e-15
C497 w_P000.n23 WIRE_CREF 8.4894619140625021e-15
C498 w_P000.n24 WIRE_CREF 2.0965271484375001e-14
C499 w_P000.n25 WIRE_CREF 1.6806667968750001e-14
C500 w_P000.n26 WIRE_CREF 1.62782109375e-14
C501 w_P000.n27 WIRE_CREF 3.3674957031250006e-14
C502 w_P000.n28 WIRE_CREF 8.3671005859375002e-15
C503 w_P000.n29 WIRE_CREF 2.8013942871093754e-15
C504 w_P000.n30 WIRE_CREF 2.5696306152343751e-15
C505 w_P000.n31 WIRE_CREF 3.9211767578124999e-15
C506 w_P000.n32 WIRE_CREF 8.4745976562499995e-15
C507 w_P000.n33 WIRE_CREF 6.6935795898437498e-15
C508 w_P000.n34 WIRE_CREF 3.9211767578124999e-15
C509 w_P000.n35 WIRE_CREF 8.4745976562499995e-15
C510 w_P000.n36 WIRE_CREF 1.0568098632812501e-14
C511 w_P000.n37 WIRE_CREF 6.9306577148437504e-15
C512 w_P000.n38 WIRE_CREF 3.2650253906250001e-15
C513 w_P000.n39 WIRE_CREF 4.7286098632812497e-15
C514 w_P000.n40 WIRE_CREF 6.8320058593750008e-15
C515 w_P000.n41 WIRE_CREF 5.4811040039062498e-15
C516 w_P000.n42 WIRE_CREF 1.1596627929687501e-14
C517 w_P000.n43 WIRE_CREF 1.7753167968749999e-14
C518 w_P000.n44 WIRE_CREF 6.4101596679687503e-15
C519 w_P000.n45 WIRE_CREF 1.0568763671875002e-14
C520 w_P000.n46 WIRE_CREF 2.2278583984375001e-14
C521 w_T0233.n0 WIRE_CREF 9.9899349212646491e-18
C522 w_T0233.n1 WIRE_CREF 4.0467300781250004e-14
C523 w_T0233.n2 WIRE_CREF 1.38477138671875e-14
C524 w_T0233.n3 WIRE_CREF 1.1034208007812501e-14
C525 w_P004.n0 WIRE_CREF 1.9617498046875e-14
C526 w_P004.n1 WIRE_CREF 1.0174223632812501e-14
C527 w_P004.n2 WIRE_CREF 6.1627841796875002e-15
C528 w_P004.n3 WIRE_CREF 2.9041230468750005e-14
C529 w_P005.n0 WIRE_CREF 1.9217736328125002e-14
C530 w_P005.n1 WIRE_CREF 8.6219863281250017e-15
C531 w_P005.n2 WIRE_CREF 4.6546088867187499e-15
C532 w_P005.n3 WIRE_CREF 2.6972017578125004e-14
C533 w_T0243.n0 WIRE_CREF 3.5357609375000002e-14
C534 w_T0243.n1 WIRE_CREF 1.6644251953125002e-14
C535 w_T0243.n2 WIRE_CREF 1.2204750976562502e-14
C536 w_T0243.n3 WIRE_CREF 1.39511259765625e-14
C537 w_T0245.n0 WIRE_CREF 3.6301519531250007e-14
C538 w_T0245.n1 WIRE_CREF 1.5522248046875001e-14
C539 w_T0245.n2 WIRE_CREF 1.1258026367187501e-14
C540 w_T0245.n3 WIRE_CREF 1.2197250976562501e-14
C541 w_T0082.n0 WIRE_CREF 2.5965662109375003e-14
C542 w_T0208.n0 WIRE_CREF 1.2551741600036622e-17
C543 w_T0208.n1 WIRE_CREF 3.1193550781250003e-14
C544 w_T0208.n2 WIRE_CREF 1.8545730468750003e-14
C545 w_T0211.n0 WIRE_CREF 1.201804542541504e-17
C546 w_T0211.n1 WIRE_CREF 3.2100263671874998e-14
C547 w_T0211.n2 WIRE_CREF 1.9947363281250002e-14
C548 w_T0110.n0 WIRE_CREF 2.3129066406250002e-14
C549 w_T0220.n0 WIRE_CREF 1.1619298934936524e-17
C550 w_T0220.n1 WIRE_CREF 2.7224953125e-14
C551 w_T0220.n2 WIRE_CREF 1.56499599609375e-14
C552 w_T0223.n0 WIRE_CREF 1.1898427963256837e-17
C553 w_T0223.n1 WIRE_CREF 3.0098058593750002e-14
C554 w_T0223.n2 WIRE_CREF 1.8197916015625003e-14
C555 w_P003.n0 WIRE_CREF 7.9125766601562508e-15
C556 w_P003.n1 WIRE_CREF 7.4689545898437511e-15
C557 w_P003.n2 WIRE_CREF 9.1701718750000001e-15
C558 w_P003.n3 WIRE_CREF 9.1701718750000001e-15
C559 w_P003.n4 WIRE_CREF 8.4757968750000008e-15
C560 w_P003.n5 WIRE_CREF 8.549173828125e-15
C561 w_P003.n6 WIRE_CREF 2.9941745605468749e-15
C562 w_P003.n7 WIRE_CREF 4.1767031250000004e-15
C563 w_P003.n8 WIRE_CREF 1.1946038818359375e-15
C564 w_P003.n9 WIRE_CREF 1.3626472656250002e-14
C565 w_P003.n10 WIRE_CREF 2.3086943359375002e-14
C566 w_P003.n11 WIRE_CREF 2.3086943359375002e-14
C567 w_P003.n12 WIRE_CREF 2.1003820312500002e-14
C568 w_P003.n13 WIRE_CREF 2.5873582031250002e-14
C569 w_P003.n14 WIRE_CREF 3.2337296875000002e-14
C570 w_P003.n15 WIRE_CREF 5.7322738281250005e-14
C571 w_P003.n16 WIRE_CREF 3.6753503906250004e-14
C572 w_P003.n17 WIRE_CREF 2.3086943359375002e-14
C573 w_P003.n18 WIRE_CREF 3.8214179687500004e-14
C574 w_P003.n19 WIRE_CREF 3.1980443359375003e-14
C575 w_P003.n20 WIRE_CREF 1.24811904296875e-14
C576 w_P003.n21 WIRE_CREF 9.1701718750000001e-15
C577 w_P003.n22 WIRE_CREF 9.1701718750000001e-15
C578 w_P003.n23 WIRE_CREF 8.4757968750000008e-15
C579 w_P003.n24 WIRE_CREF 1.3592919921875001e-14
C580 w_P003.n25 WIRE_CREF 1.1355707031250002e-14
C581 w_P003.n26 WIRE_CREF 5.4176191406250003e-15
C582 w_P003.n27 WIRE_CREF 1.1537783203125002e-14
C583 w_P003.n28 WIRE_CREF 3.5614292968750004e-14
C584 w_T0242.n0 WIRE_CREF 6.3363148437500007e-14
C585 w_T0242.n1 WIRE_CREF 4.4294957031250003e-14
C586 w_T0242.n2 WIRE_CREF 1.2126960937500001e-14
C587 w_T0240.n0 WIRE_CREF 6.2812093750000009e-14
C588 w_T0240.n1 WIRE_CREF 4.4741371093750003e-14
C589 w_T0240.n2 WIRE_CREF 1.2898221679687501e-14
C590 w_P006.n0 WIRE_CREF 2.2932035156250001e-14
C591 w_P006.n1 WIRE_CREF 1.9878369140625002e-14
C592 w_P006.n2 WIRE_CREF 1.889776953125e-14
C593 w_P006.n3 WIRE_CREF 1.889776953125e-14
C594 w_P006.n4 WIRE_CREF 1.889776953125e-14
C595 w_P006.n5 WIRE_CREF 2.6262156250000001e-14
C596 w_P006.n6 WIRE_CREF 2.7290453125000003e-14
C597 w_P006.n7 WIRE_CREF 1.9403451171874999e-14
C598 w_P006.n8 WIRE_CREF 1.9403451171874999e-14
C599 w_P006.n9 WIRE_CREF 1.9403451171874999e-14
C600 w_P006.n10 WIRE_CREF 2.7300044921875002e-14
C601 w_P006.n11 WIRE_CREF 1.3056208007812502e-14
C602 w_P006.n12 WIRE_CREF 1.783094921875e-14
C603 w_P006.n13 WIRE_CREF 1.9403451171874999e-14
C604 w_P006.n14 WIRE_CREF 1.9403451171874999e-14
C605 w_P006.n15 WIRE_CREF 1.9403451171874999e-14
C606 w_P006.n16 WIRE_CREF 2.7300044921875002e-14
C607 w_T0188.n0 WIRE_CREF 1.0817708969116212e-17
C608 w_T0188.n1 WIRE_CREF 1.1478928710937502e-14
C609 w_T0188.n2 WIRE_CREF 1.6714845703125001e-14
C610 w_T0239.n0 WIRE_CREF 1.51826484375e-14
C611 w_T0239.n1 WIRE_CREF 1.8035529296875002e-14
C612 w_T0241.n0 WIRE_CREF 1.8735847656250002e-14
C613 w_T0241.n1 WIRE_CREF 1.7395427734375002e-14
C614 w_T0181.n0 WIRE_CREF 1.0419066429138185e-17
C615 w_T0181.n1 WIRE_CREF 2.3767935546875003e-14
C616 w_T0184.n0 WIRE_CREF 1.0342905044555665e-17
C617 w_T0184.n1 WIRE_CREF 2.2839113281250003e-14
C618 w_T0084.n0 WIRE_CREF 2.0562439453125e-14
C619 w_T0175.n0 WIRE_CREF 4.5328527343750003e-14
C620 w_T0175.n1 WIRE_CREF 1.0709571289062501e-14
C621 w_T0175.n2 WIRE_CREF 6.4742446289062507e-15
C622 w_T0175.n3 WIRE_CREF 3.1934699218750002e-14
C623 w_T0178.n0 WIRE_CREF 4.5182347656250008e-14
C624 w_T0178.n1 WIRE_CREF 1.1626992187500002e-14
C625 w_T0178.n2 WIRE_CREF 7.4546796874999995e-15
C626 w_T0178.n3 WIRE_CREF 3.2482160156250008e-14
C627 w_T0161.n0 WIRE_CREF 1.008462142944336e-17
C628 w_T0161.n1 WIRE_CREF 4.1854281250000004e-14
C629 w_T0161.n2 WIRE_CREF 1.4451893554687502e-14
C630 w_T0161.n3 WIRE_CREF 1.2095923828125001e-14
C631 w_T0170.n0 WIRE_CREF 4.0976742187500006e-14
C632 w_T0170.n1 WIRE_CREF 2.1732744140625003e-14
C633 w_T0173.n0 WIRE_CREF 4.1070476562499999e-14
C634 w_T0173.n1 WIRE_CREF 2.5154949218750003e-14
C635 w_T0235.n0 WIRE_CREF 3.6150972656250002e-14
C636 w_T0235.n1 WIRE_CREF 1.701012890625e-14
C637 w_T0235.n2 WIRE_CREF 1.2601019531250001e-14
C638 w_T0235.n3 WIRE_CREF 1.4812509765625002e-14
C639 w_T0237.n0 WIRE_CREF 3.7177937500000001e-14
C640 w_T0237.n1 WIRE_CREF 1.5935255859375e-14
C641 w_T0237.n2 WIRE_CREF 1.1696253906250001e-14
C642 w_T0237.n3 WIRE_CREF 1.3106556640625001e-14
C643 w_T0010.n0 WIRE_CREF 2.7385654296875001e-14
C644 w_T0136.n0 WIRE_CREF 1.230834197998047e-17
C645 w_T0136.n1 WIRE_CREF 3.1741142578125002e-14
C646 w_T0136.n2 WIRE_CREF 1.9252607421875e-14
C647 w_T0139.n0 WIRE_CREF 1.2034614562988282e-17
C648 w_T0139.n1 WIRE_CREF 3.3266605468750003e-14
C649 w_T0139.n2 WIRE_CREF 2.1015671874999999e-14
C650 w_T0034.n0 WIRE_CREF 2.4563136718750001e-14
C651 w_T0148.n0 WIRE_CREF 1.1662702560424805e-17
C652 w_T0148.n1 WIRE_CREF 2.8434378906250002e-14
C653 w_T0148.n2 WIRE_CREF 1.6725773437500001e-14
C654 w_T0151.n0 WIRE_CREF 1.1849100112915041e-17
C655 w_T0151.n1 WIRE_CREF 3.1093056640625001e-14
C656 w_T0151.n2 WIRE_CREF 1.915359765625e-14
.ends nssoc_clock_div4_v7_power_v2_hybrid_open_v1
