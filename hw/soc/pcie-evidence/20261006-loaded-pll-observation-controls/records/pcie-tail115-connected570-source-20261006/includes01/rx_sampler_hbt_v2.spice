* SPDX-FileCopyrightText: 2026 Hasan Melih Akbulut
* SPDX-License-Identifier: CERN-OHL-W-2.0
* Development CML master/slave sampler, not a CDR or complete PCIe PHY.
* External AVDD=2.5 V, AVSS=0 V, IREF=0.5 mA and differential clock required.
* RX v2 remains separately powered from 1.8 V. Native resistive level shift
* loads its actual outputs; no ideal voltage gain or behavioral latch exists.
* Clock target: 8 GHz, common mode 1.29 V, differential levels +/-0.30 V.
* Preamplifier/substrate/pad parasitics are not supplied by this schematic.

.subckt nssoc_cml_latch dp dn qp qn cp cn avdd avss sub ref
XDP qn dp se sub npn13G2 Nx=2
XDN qp dn se sub npn13G2 Nx=2
XLP qn qp he sub npn13G2 Nx=2
XLN qp qn he sub npn13G2 Nx=2
XCS se cp te sub npn13G2 Nx=4
XCH he cn te sub npn13G2 Nx=4
XT te ref avss sub npn13G2 Nx=4
XRP avdd qp sub rppd w=8u l=2.12u b=0 sw_et=1
XRN avdd qn sub rppd w=8u l=2.12u b=0 sw_et=1
* Weak native bleeders keep the inactive emitter nodes from floating.
XBS se avss sub rppd w=1u l=38.4u b=0 sw_et=1
XBH he avss sub rppd w=1u l=38.4u b=0 sw_et=1
.ends nssoc_cml_latch

.subckt nssoc_rx_sampler_hbt dp dn qp qn clkp clkn avdd avss sub iref
XREF iref iref avss sub npn13G2 Nx=1
XIP dp lp sub rppd w=1u l=3.6u b=0 sw_et=1
XIN dn ln sub rppd w=1u l=3.6u b=0 sw_et=1
XBP avdd lp sub rppd w=1u l=3.6u b=0 sw_et=1
XBN avdd ln sub rppd w=1u l=3.6u b=0 sw_et=1
* Master tracks low clock; slave tracks high clock, capturing a rising edge.
XM lp ln mp mn clkn clkp avdd avss sub iref nssoc_cml_latch
XS mp mn qp qn clkp clkn avdd avss sub iref nssoc_cml_latch
.ends nssoc_rx_sampler_hbt
