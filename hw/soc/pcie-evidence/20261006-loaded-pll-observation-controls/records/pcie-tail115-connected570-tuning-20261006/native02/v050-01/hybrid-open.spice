* Exact 62-device / 151-anchor integration PILOT. NOT closed body PEX.
* BODY_SUBSTRATE requires an explicit external boundary assumption.
* WIRE_CREF is NOT mapped to an intrinsic body/supply.
.subckt nssoc_vco_local_hybrid_open_v2 AVDD AVSS CLKN CLKP SUB VCTRL BODY_SUBSTRATE WIRE_CREF
XD0001 w_T0000 body_well_2 ntap1 R=81.66666666666666666666666668 w=2u l=2u
XD0002 w_T0004 w_T0003 w_T0002 body_well_2 sg13_hv_pmos l=0.45u w=8.0u as=2.72p ad=2.72p ps=16.68u pd=16.68u rfmode=0.0 ng=1 m=1
XD0003 w_T0008 w_T0007 w_T0006 body_well_2 sg13_hv_pmos l=0.45u w=8.0u as=2.72p ad=2.72p ps=16.68u pd=16.68u rfmode=0.0 ng=1 m=1
XD0004 w_T0012 w_T0011 w_T0010 body_well_2 sg13_hv_pmos l=0.45u w=8.0u as=2.72p ad=2.72p ps=16.68u pd=16.68u rfmode=0.0 ng=1 m=1
XD0005 w_T0016 w_T0015 w_T0014 body_well_2 sg13_hv_pmos l=0.45u w=8.0u as=2.72p ad=2.72p ps=16.68u pd=16.68u rfmode=0.0 ng=1 m=1
XD0006 w_T0018 w_T0019 w_T0020 BODY_SUBSTRATE npn13G2 Nx=1 we=0.07u le=0.9u
XD0007 w_T0022 w_T0023 w_T0024 BODY_SUBSTRATE npn13G2 Nx=1 we=0.07u le=0.9u
XD0008 w_T0026 w_T0027 BODY_SUBSTRATE rppd w=2.0u l=7.4u ps=0.0u b=0 m=1 sw_et=1
XD0009 w_T0029 w_T0030 cap_cmim w=11.2u l=11.0u
XD0010 w_T0031 w_T0032 BODY_SUBSTRATE rppd w=8.0u l=4.4u ps=0.0u b=0 m=1 sw_et=1
XD0011 w_T0034 w_T0035 BODY_SUBSTRATE rppd w=8.0u l=4.4u ps=0.0u b=0 m=1 sw_et=1
XD0012 w_T0037 w_T0038 BODY_SUBSTRATE rppd w=8.0u l=4.4u ps=0.0u b=0 m=1 sw_et=1
XD0013 w_T0040 w_T0041 BODY_SUBSTRATE rppd w=8.0u l=4.4u ps=0.0u b=0 m=1 sw_et=1
XD0014 w_T0043 w_T0044 BODY_SUBSTRATE rppd w=8.0u l=4.4u ps=0.0u b=0 m=1 sw_et=1
XD0015 w_T0046 w_T0047 BODY_SUBSTRATE rppd w=8.0u l=4.4u ps=0.0u b=0 m=1 sw_et=1
XD0016 w_T0049 BODY_SUBSTRATE ptap1 R=81.66666666666666666666666668 w=2u l=2u
XD0017 w_T0051 BODY_SUBSTRATE ptap1 R=81.66666666666666666666666668 w=2u l=2u
XD0018 w_T0053 BODY_SUBSTRATE ptap1 R=81.66666666666666666666666668 w=2u l=2u
XD0019 w_T0055 BODY_SUBSTRATE ptap1 R=81.66666666666666666666666668 w=2u l=2u
XD0020 w_T0057 BODY_SUBSTRATE ptap1 R=81.66666666666666666666666668 w=2u l=2u
XD0021 w_T0059 BODY_SUBSTRATE ptap1 R=81.66666666666666666666666668 w=2u l=2u
XD0022 w_T0061 BODY_SUBSTRATE ptap1 R=81.66666666666666666666666668 w=2u l=2u
XD0023 w_T0063 BODY_SUBSTRATE ptap1 R=81.66666666666666666666666668 w=2u l=2u
XD0024 w_T0065 BODY_SUBSTRATE ptap1 R=81.66666666666666666666666668 w=2u l=2u
XD0025 w_T0067 BODY_SUBSTRATE ptap1 R=81.66666666666666666666666668 w=2u l=2u
XD0026 w_T0069 BODY_SUBSTRATE ptap1 R=81.66666666666666666666666668 w=2u l=2u
XD0027 w_T0071 BODY_SUBSTRATE ptap1 R=81.66666666666666666666666668 w=2u l=2u
XD0028 w_T0073 w_T0074 cap_cmim w=11.0u l=11.0u
XD0029 w_T0075 w_T0076 cap_cmim w=11.0u l=11.0u
XD0030 w_T0077 w_T0078 cap_cmim w=11.0u l=11.0u
XD0031 w_T0079 w_T0080 cap_cmim w=11.0u l=11.0u
XD0032 w_T0081 w_T0082 cap_cmim w=11.0u l=11.0u
XD0033 w_T0083 w_T0084 BODY_SUBSTRATE rppd w=8.0u l=4.0u ps=0.0u b=0 m=1 sw_et=1
XD0034 w_T0086 w_T0087 BODY_SUBSTRATE rppd w=8.0u l=4.0u ps=0.0u b=0 m=1 sw_et=1
XD0035 w_T0089 w_T0090 w_T0091 BODY_SUBSTRATE npn13G2 Nx=4 we=0.07u le=0.9u
XD0036 w_T0093 w_T0094 w_T0095 BODY_SUBSTRATE npn13G2 Nx=4 we=0.07u le=0.9u
XD0037 w_T0097 w_T0098 w_T0099 BODY_SUBSTRATE npn13G2 Nx=4 we=0.07u le=0.9u
XD0038 w_T0101 w_T0102 w_T0103 BODY_SUBSTRATE npn13G2 Nx=4 we=0.07u le=0.9u
XD0039 w_T0105 w_T0106 w_T0107 BODY_SUBSTRATE npn13G2 Nx=4 we=0.07u le=0.9u
XD0040 w_T0109 w_T0110 w_T0111 BODY_SUBSTRATE npn13G2 Nx=4 we=0.07u le=0.9u
XD0041 w_T0113 w_T0114 w_T0115 BODY_SUBSTRATE npn13G2 Nx=4 we=0.07u le=0.9u
XD0042 w_T0117 w_T0118 w_T0119 BODY_SUBSTRATE npn13G2 Nx=4 we=0.07u le=0.9u
XD0043 w_T0121 w_T0122 w_T0123 BODY_SUBSTRATE npn13G2 Nx=4 we=0.07u le=0.9u
XD0044 w_T0125 w_T0126 w_T0127 BODY_SUBSTRATE npn13G2 Nx=4 we=0.07u le=0.9u
XD0045 w_T0129 w_T0130 w_T0131 BODY_SUBSTRATE npn13G2 Nx=4 we=0.07u le=0.9u
XD0046 w_T0133 w_T0134 w_T0135 BODY_SUBSTRATE npn13G2 Nx=2 we=0.07u le=0.9u
XD0047 w_T0137 w_T0138 w_T0139 BODY_SUBSTRATE npn13G2 Nx=2 we=0.07u le=0.9u
XD0048 w_T0141 w_T0142 w_T0143 BODY_SUBSTRATE npn13G2 Nx=2 we=0.07u le=0.9u
XD0049 w_T0145 w_T0146 w_T0147 BODY_SUBSTRATE npn13G2 Nx=2 we=0.07u le=0.9u
XD0050 w_T0149 w_T0150 w_T0151 BODY_SUBSTRATE npn13G2 Nx=2 we=0.07u le=0.9u
XD0051 w_T0153 w_T0154 w_T0155 BODY_SUBSTRATE npn13G2 Nx=2 we=0.07u le=0.9u
XD0052 w_T0157 w_T0158 w_T0159 BODY_SUBSTRATE npn13G2 Nx=2 we=0.07u le=0.9u
XD0053 w_T0161 w_T0162 w_T0163 BODY_SUBSTRATE npn13G2 Nx=2 we=0.07u le=0.9u
XD0054 w_T0165 w_T0166 w_T0167 BODY_SUBSTRATE npn13G2 Nx=2 we=0.07u le=0.9u
XD0055 w_T0169 w_T0170 w_T0171 BODY_SUBSTRATE npn13G2 Nx=2 we=0.07u le=0.9u
XD0056 w_T0173 w_T0174 w_T0175 BODY_SUBSTRATE npn13G2 Nx=2 we=0.07u le=0.9u
XD0057 w_T0177 w_T0178 w_T0179 BODY_SUBSTRATE npn13G2 Nx=2 we=0.07u le=0.9u
XD0058 w_T0181 w_T0182 w_T0183 BODY_SUBSTRATE npn13G2 Nx=2 we=0.07u le=0.9u
XD0059 w_T0185 w_T0186 w_T0187 BODY_SUBSTRATE npn13G2 Nx=2 we=0.07u le=0.9u
XD0060 w_T0189 w_T0190 w_T0191 BODY_SUBSTRATE npn13G2 Nx=2 we=0.07u le=0.9u
XD0061 w_T0193 w_T0194 w_T0195 BODY_SUBSTRATE npn13G2 Nx=2 we=0.07u le=0.9u
XD0062 w_T0197 w_T0198 w_T0199 BODY_SUBSTRATE npn13G2 Nx=2 we=0.07u le=0.9u
R0 SUB w_P004.n0 0.308
R1 w_P004.n1 w_P004.n0 0.176
R2 w_P004.n2 w_P004.n1 0.176
R3 w_P004.n3 w_P004.n2 0.176
R4 w_P004.n4 w_P004.n3 0.176
R5 w_P004.n5 w_P004.n4 0.176
R6 w_P004.n6 w_P004.n5 0.176
R7 w_P004.n7 w_P004.n6 0.176
R8 w_P004.n8 w_P004.n7 0.176
R9 w_P004.n9 w_P004.n8 0.176
R10 w_P004.n10 w_P004.n9 0.176
R11 w_T0051 w_P004.n10 40.4319
R12 w_T0071 w_P004.n10 40.2559
R13 w_T0059 w_P004.n9 40.2559
R14 w_T0069 w_P004.n8 40.2559
R15 w_T0067 w_P004.n7 40.2559
R16 w_T0065 w_P004.n6 40.2559
R17 w_T0063 w_P004.n5 40.2559
R18 w_T0061 w_P004.n4 40.2559
R19 w_T0057 w_P004.n3 40.2559
R20 w_T0055 w_P004.n2 40.2559
R21 w_T0053 w_P004.n1 40.2559
R22 w_T0049 w_P004.n0 40.2559
R23 w_T0185.n1 w_T0185.n0 0.0722684
R24 w_T0185.n2 w_T0185.n3 9
R25 w_T0185.n4 w_T0185.n5 9
R26 w_T0185.n6 w_T0185 2.47081
R27 w_T0185 w_T0185.n4 0.06
R28 w_T0185.n2 w_T0185.n4 0.12
R29 w_T0185.n0 w_T0185.n2 4.61418
R30 w_T0185.n0 w_T0185.n7 9.07323
R31 w_T0185.n3 w_T0185.n8 9
R32 w_T0185.n1 w_T0185.n33 9
R33 w_T0185.n6 w_T0185.n5 0.202415
R34 w_T0185.n5 w_T0185.n3 0.145655
R35 w_T0185.n3 w_T0185.n1 0.145655
R36 w_T0185.n8 w_T0185.n6 2.0097
R37 w_T0185.n33 w_T0185.n8 0.1056
R38 w_T0185.n7 w_T0185.n33 0.1056
R39 w_T0185.n9 w_T0185.n7 6.03508
R40 w_T0185.n9 w_T0185.n10 9
R41 w_T0185.n9 w_T0185.n11 9
R42 w_T0185.n10 w_T0185.n12 0.0110476
R43 w_T0185.n32 w_T0185.n12 4.51283
R44 w_T0185.n32 w_T0185.n9 0.0176
R45 w_T0185.n13 w_T0185.n32 4.54085
R46 w_T0185.n32 w_T0185.n14 4.54085
R47 w_T0185.n31 w_T0185.n25 4.54085
R48 w_T0185.n26 w_T0185.n27 9
R49 w_T0185.n26 w_T0185.n28 9
R50 w_T0185.n31 w_T0185.n29 4.54085
R51 w_T0185.n30 w_T0185.n27 0.0110476
R52 w_T0185.n31 w_T0185.n30 4.51283
R53 w_T0185.n14 w_T0185.n15 15.7626
R54 w_T0185.n11 w_T0185.n14 0.02112
R55 w_T0185.n12 w_T0185.n11 0.0110476
R56 w_T0185.n13 w_T0185.n10 0.02112
R57 w_T0185.n29 w_T0185.n13 1.25664
R58 w_T0185.n29 w_T0185.n28 0.02112
R59 w_T0185.n30 w_T0185.n28 0.0110476
R60 w_T0185.n27 w_T0185.n25 0.02112
R61 w_T0185.n25 w_T0075 11.326
R62 w_T0185.n26 w_T0185.n31 0.0176
R63 w_T0032 w_T0185.n26 13.4834
R64 w_T0185.n17 w_T0185.n16 0.201685
R65 w_T0185.n18 w_T0185.n19 9
R66 w_T0185.n20 w_T0185.n21 9
R67 w_T0185.n19 w_T0185.n17 2.0099
R68 w_T0185.n21 w_T0185.n19 0.1056
R69 w_T0185.n15 w_T0185.n21 0.1056
R70 w_T0185.n20 w_T0185.n22 0.0720603
R71 w_T0185.n23 w_T0185.n18 9
R72 w_T0185.n24 w_T0185.n16 9
R73 w_T0154 w_T0185.n17 2.54138
R74 w_T0185.n16 w_T0185.n18 0.145655
R75 w_T0185.n18 w_T0185.n20 0.145655
R76 w_T0185.n22 w_T0185.n15 9.07344
R77 w_T0154 w_T0185.n24 0.0865574
R78 w_T0185.n23 w_T0185.n24 0.173115
R79 w_T0185.n22 w_T0185.n23 4.68036
R80 w_T0193.n1 w_T0193.n0 0.0722684
R81 w_T0193.n2 w_T0193.n3 9
R82 w_T0193.n4 w_T0193.n5 9
R83 w_T0193.n6 w_T0193 2.47081
R84 w_T0193 w_T0193.n4 0.06
R85 w_T0193.n2 w_T0193.n4 0.12
R86 w_T0193.n0 w_T0193.n2 4.61418
R87 w_T0193.n0 w_T0193.n7 9.07323
R88 w_T0193.n3 w_T0193.n8 9
R89 w_T0193.n1 w_T0193.n34 9
R90 w_T0193.n6 w_T0193.n5 0.202415
R91 w_T0193.n5 w_T0193.n3 0.145655
R92 w_T0193.n3 w_T0193.n1 0.145655
R93 w_T0193.n8 w_T0193.n6 2.0097
R94 w_T0193.n34 w_T0193.n8 0.1056
R95 w_T0193.n7 w_T0193.n34 0.1056
R96 w_T0193.n21 w_T0193.n7 8.16056
R97 w_T0193.n9 w_T0193.n16 4.54085
R98 w_T0193.n10 w_T0193.n11 9
R99 w_T0193.n10 w_T0193.n12 9
R100 w_T0193.n16 w_T0193.n13 4.54085
R101 w_T0193.n11 w_T0193.n14 0.0110476
R102 w_T0193.n14 w_T0193.n15 4.49523
R103 w_T0193.n17 w_T0193.n23 4.54085
R104 w_T0193.n18 w_T0193.n19 9
R105 w_T0193.n18 w_T0193.n20 9
R106 w_T0193.n23 w_T0193.n21 4.54085
R107 w_T0193.n19 w_T0193.n22 0.0110476
R108 w_T0193.n23 w_T0193.n22 4.51283
R109 w_T0193.n20 w_T0193.n21 0.02112
R110 w_T0193.n22 w_T0193.n20 0.0110476
R111 w_T0193.n17 w_T0193.n19 0.02112
R112 w_T0193.n13 w_T0193.n17 0.86064
R113 w_T0193.n12 w_T0193.n13 0.02112
R114 w_T0193.n14 w_T0193.n12 0.0110476
R115 w_T0193.n9 w_T0193.n11 0.02112
R116 w_T0193.n24 w_T0193.n9 9.52931
R117 w_T0193.n26 w_T0193.n25 0.201685
R118 w_T0193.n27 w_T0193.n28 9
R119 w_T0193.n29 w_T0193.n30 9
R120 w_T0193.n26 w_T0193.n28 2.0099
R121 w_T0193.n28 w_T0193.n30 0.1056
R122 w_T0193.n30 w_T0193.n24 0.1056
R123 w_T0193.n29 w_T0193.n31 0.0720603
R124 w_T0193.n32 w_T0193.n27 9
R125 w_T0193.n33 w_T0193.n25 9
R126 w_T0186 w_T0193.n26 2.54138
R127 w_T0193.n25 w_T0193.n27 0.145655
R128 w_T0193.n27 w_T0193.n29 0.145655
R129 w_T0193.n31 w_T0193.n24 9.07344
R130 w_T0186 w_T0193.n33 0.0865574
R131 w_T0193.n33 w_T0193.n32 0.173115
R132 w_T0193.n32 w_T0193.n31 4.68036
R133 w_T0193.n23 w_T0193.n18 0.0176
R134 w_T0038 w_T0193.n18 13.1901
R135 w_T0193.n16 w_T0193.n10 0.0176
R136 w_T0193.n16 w_T0193.n15 0.0176
R137 w_T0193.n15 w_T0081 9.59652
R138 w_T0194.n1 w_T0194.n0 0.0720603
R139 w_T0194.n2 w_T0194.n3 9
R140 w_T0194.n4 w_T0194.n5 9
R141 w_T0194.n6 w_T0194 2.54047
R142 w_T0194 w_T0194.n4 0.0865574
R143 w_T0194.n2 w_T0194.n4 0.173115
R144 w_T0194.n0 w_T0194.n2 4.68036
R145 w_T0194.n0 w_T0194.n7 9.07344
R146 w_T0194.n3 w_T0194.n8 9
R147 w_T0194.n1 w_T0194.n41 9
R148 w_T0194.n6 w_T0194.n5 0.201668
R149 w_T0194.n5 w_T0194.n3 0.145655
R150 w_T0194.n3 w_T0194.n1 0.145655
R151 w_T0194.n8 w_T0194.n6 2.01046
R152 w_T0194.n41 w_T0194.n8 0.1056
R153 w_T0194.n7 w_T0194.n41 0.1056
R154 w_T0194.n9 w_T0194.n7 9.23589
R155 w_T0194.n16 w_T0194.n9 4.54085
R156 w_T0194.n10 w_T0194.n11 9
R157 w_T0194.n10 w_T0194.n12 9
R158 w_T0194.n13 w_T0194.n16 4.54085
R159 w_T0194.n14 w_T0194.n11 0.0110476
R160 w_T0194.n14 w_T0194.n15 4.49523
R161 w_T0194.n17 w_T0194.n23 4.54085
R162 w_T0194.n18 w_T0194.n19 9
R163 w_T0194.n18 w_T0194.n20 9
R164 w_T0194.n23 w_T0194.n21 4.54085
R165 w_T0194.n19 w_T0194.n22 0.0110476
R166 w_T0194.n23 w_T0194.n22 4.51283
R167 w_T0194.n40 w_T0194.n34 4.54085
R168 w_T0194.n35 w_T0194.n36 9
R169 w_T0194.n35 w_T0194.n37 9
R170 w_T0194.n40 w_T0194.n38 4.54085
R171 w_T0194.n39 w_T0194.n36 0.0110476
R172 w_T0194.n40 w_T0194.n39 4.51283
R173 w_T0134 w_T0194.n21 13.209
R174 w_T0194.n20 w_T0194.n21 0.02112
R175 w_T0194.n22 w_T0194.n20 0.0110476
R176 w_T0194.n17 w_T0194.n19 0.02112
R177 w_T0194.n38 w_T0194.n17 1.25664
R178 w_T0194.n38 w_T0194.n37 0.02112
R179 w_T0194.n39 w_T0194.n37 0.0110476
R180 w_T0194.n36 w_T0194.n34 0.02112
R181 w_T0194.n34 w_T0194.n13 0.86064
R182 w_T0194.n13 w_T0194.n12 0.02112
R183 w_T0194.n12 w_T0194.n14 0.0110476
R184 w_T0194.n11 w_T0194.n9 0.02112
R185 w_T0194.n35 w_T0194.n40 0.0176
R186 w_T0047 w_T0194.n35 12.8967
R187 w_T0194.n18 w_T0194.n24 5.44842
R188 w_T0194.n23 w_T0194.n18 0.0176
R189 w_T0194.n26 w_T0194.n25 0.20243
R190 w_T0194.n27 w_T0194.n28 9
R191 w_T0194.n29 w_T0194.n30 9
R192 w_T0194.n28 w_T0194.n26 2.00914
R193 w_T0194.n30 w_T0194.n28 0.1056
R194 w_T0194.n24 w_T0194.n30 0.1056
R195 w_T0194.n29 w_T0194.n31 0.0722684
R196 w_T0194.n32 w_T0194.n27 9
R197 w_T0194.n33 w_T0194.n25 9
R198 w_T0153 w_T0194.n26 2.47172
R199 w_T0194.n25 w_T0194.n27 0.145655
R200 w_T0194.n27 w_T0194.n29 0.145655
R201 w_T0194.n31 w_T0194.n24 9.07323
R202 w_T0153 w_T0194.n33 0.06
R203 w_T0194.n32 w_T0194.n33 0.12
R204 w_T0194.n31 w_T0194.n32 4.61418
R205 w_T0194.n16 w_T0194.n10 0.0176
R206 w_T0194.n16 w_T0194.n15 0.0176
R207 w_T0194.n15 w_T0029 9.8891
R208 w_T0181.n1 w_T0181.n0 0.0722684
R209 w_T0181.n2 w_T0181.n3 9
R210 w_T0181.n4 w_T0181.n5 9
R211 w_T0181.n6 w_T0181 2.47081
R212 w_T0181 w_T0181.n4 0.06
R213 w_T0181.n2 w_T0181.n4 0.12
R214 w_T0181.n0 w_T0181.n2 4.61418
R215 w_T0181.n0 w_T0181.n7 9.07323
R216 w_T0181.n3 w_T0181.n8 9
R217 w_T0181.n1 w_T0181.n33 9
R218 w_T0181.n6 w_T0181.n5 0.202415
R219 w_T0181.n5 w_T0181.n3 0.145655
R220 w_T0181.n3 w_T0181.n1 0.145655
R221 w_T0181.n8 w_T0181.n6 2.0097
R222 w_T0181.n33 w_T0181.n8 0.1056
R223 w_T0181.n7 w_T0181.n33 0.1056
R224 w_T0181.n9 w_T0181.n7 8.01508
R225 w_T0181.n9 w_T0181.n10 9
R226 w_T0181.n9 w_T0181.n11 9
R227 w_T0181.n10 w_T0181.n12 0.0110476
R228 w_T0181.n32 w_T0181.n12 4.51283
R229 w_T0181.n32 w_T0181.n9 0.0176
R230 w_T0181.n13 w_T0181.n32 4.54085
R231 w_T0181.n32 w_T0181.n14 4.54085
R232 w_T0181.n31 w_T0181.n25 4.54085
R233 w_T0181.n26 w_T0181.n27 9
R234 w_T0181.n26 w_T0181.n28 9
R235 w_T0181.n31 w_T0181.n29 4.54085
R236 w_T0181.n30 w_T0181.n27 0.0110476
R237 w_T0181.n31 w_T0181.n30 4.51283
R238 w_T0181.n14 w_T0181.n15 17.7426
R239 w_T0181.n11 w_T0181.n14 0.02112
R240 w_T0181.n12 w_T0181.n11 0.0110476
R241 w_T0181.n13 w_T0181.n10 0.02112
R242 w_T0181.n29 w_T0181.n13 1.25664
R243 w_T0181.n29 w_T0181.n28 0.02112
R244 w_T0181.n30 w_T0181.n28 0.0110476
R245 w_T0181.n27 w_T0181.n25 0.02112
R246 w_T0181.n25 w_T0077 11.3935
R247 w_T0181.n26 w_T0181.n31 0.0176
R248 w_T0044 w_T0181.n26 14.1434
R249 w_T0181.n17 w_T0181.n16 0.201685
R250 w_T0181.n18 w_T0181.n19 9
R251 w_T0181.n20 w_T0181.n21 9
R252 w_T0181.n19 w_T0181.n17 2.0099
R253 w_T0181.n21 w_T0181.n19 0.1056
R254 w_T0181.n15 w_T0181.n21 0.1056
R255 w_T0181.n20 w_T0181.n22 0.0720603
R256 w_T0181.n23 w_T0181.n18 9
R257 w_T0181.n24 w_T0181.n16 9
R258 w_T0178 w_T0181.n17 2.54138
R259 w_T0181.n16 w_T0181.n18 0.145655
R260 w_T0181.n18 w_T0181.n20 0.145655
R261 w_T0181.n22 w_T0181.n15 9.07344
R262 w_T0178 w_T0181.n24 0.0865574
R263 w_T0181.n23 w_T0181.n24 0.173115
R264 w_T0181.n22 w_T0181.n23 4.68036
R265 w_T0182.n1 w_T0182.n0 0.0720603
R266 w_T0182.n2 w_T0182.n3 9
R267 w_T0182.n4 w_T0182.n5 9
R268 w_T0182.n6 w_T0182 2.54047
R269 w_T0182 w_T0182.n4 0.0865574
R270 w_T0182.n2 w_T0182.n4 0.173115
R271 w_T0182.n0 w_T0182.n2 4.68036
R272 w_T0182.n0 w_T0182.n7 9.07344
R273 w_T0182.n3 w_T0182.n8 9
R274 w_T0182.n1 w_T0182.n34 9
R275 w_T0182.n6 w_T0182.n5 0.201668
R276 w_T0182.n5 w_T0182.n3 0.145655
R277 w_T0182.n3 w_T0182.n1 0.145655
R278 w_T0182.n8 w_T0182.n6 2.01046
R279 w_T0182.n34 w_T0182.n8 0.1056
R280 w_T0182.n7 w_T0182.n34 0.1056
R281 w_T0182.n9 w_T0182.n7 11.5092
R282 w_T0182.n16 w_T0182.n9 4.54085
R283 w_T0182.n10 w_T0182.n11 9
R284 w_T0182.n10 w_T0182.n12 9
R285 w_T0182.n13 w_T0182.n16 4.54085
R286 w_T0182.n14 w_T0182.n11 0.0110476
R287 w_T0182.n14 w_T0182.n15 4.49523
R288 w_T0182.n33 w_T0182.n27 4.54085
R289 w_T0182.n28 w_T0182.n29 9
R290 w_T0182.n28 w_T0182.n30 9
R291 w_T0182.n33 w_T0182.n31 4.54085
R292 w_T0182.n32 w_T0182.n29 0.0110476
R293 w_T0182.n33 w_T0182.n32 4.51283
R294 w_T0182.n31 w_T0182.n17 10.1408
R295 w_T0182.n31 w_T0182.n30 0.02112
R296 w_T0182.n32 w_T0182.n30 0.0110476
R297 w_T0182.n29 w_T0182.n27 0.02112
R298 w_T0182.n27 w_T0182.n13 0.86064
R299 w_T0182.n13 w_T0182.n12 0.02112
R300 w_T0182.n12 w_T0182.n14 0.0110476
R301 w_T0182.n11 w_T0182.n9 0.02112
R302 w_T0182.n28 w_T0182.n33 0.0176
R303 w_T0035 w_T0182.n28 13.8501
R304 w_T0182.n19 w_T0182.n18 0.20243
R305 w_T0182.n20 w_T0182.n21 9
R306 w_T0182.n22 w_T0182.n23 9
R307 w_T0182.n21 w_T0182.n19 2.00914
R308 w_T0182.n23 w_T0182.n21 0.1056
R309 w_T0182.n17 w_T0182.n23 0.1056
R310 w_T0182.n22 w_T0182.n24 0.0722684
R311 w_T0182.n25 w_T0182.n20 9
R312 w_T0182.n26 w_T0182.n18 9
R313 w_T0173 w_T0182.n19 2.47172
R314 w_T0182.n18 w_T0182.n20 0.145655
R315 w_T0182.n20 w_T0182.n22 0.145655
R316 w_T0182.n24 w_T0182.n17 9.07323
R317 w_T0173 w_T0182.n26 0.06
R318 w_T0182.n25 w_T0182.n26 0.12
R319 w_T0182.n24 w_T0182.n25 4.61418
R320 w_T0182.n16 w_T0182.n10 0.0176
R321 w_T0182.n16 w_T0182.n15 0.0176
R322 w_T0182.n15 w_T0079 9.66402
R323 w_T0177.n1 w_T0177.n0 0.0722684
R324 w_T0177.n2 w_T0177.n3 9
R325 w_T0177.n4 w_T0177.n5 9
R326 w_T0177.n6 w_T0177 2.47081
R327 w_T0177 w_T0177.n4 0.06
R328 w_T0177.n2 w_T0177.n4 0.12
R329 w_T0177.n0 w_T0177.n2 4.61418
R330 w_T0177.n0 w_T0177.n7 9.07323
R331 w_T0177.n3 w_T0177.n8 9
R332 w_T0177.n1 w_T0177.n41 9
R333 w_T0177.n6 w_T0177.n5 0.202415
R334 w_T0177.n5 w_T0177.n3 0.145655
R335 w_T0177.n3 w_T0177.n1 0.145655
R336 w_T0177.n8 w_T0177.n6 2.0097
R337 w_T0177.n41 w_T0177.n8 0.1056
R338 w_T0177.n7 w_T0177.n41 0.1056
R339 w_T0177.n9 w_T0177.n7 7.42841
R340 w_T0177.n9 w_T0177.n10 9
R341 w_T0177.n9 w_T0177.n11 9
R342 w_T0177.n10 w_T0177.n12 0.0110476
R343 w_T0177.n40 w_T0177.n12 4.51283
R344 w_T0177.n40 w_T0177.n9 0.0176
R345 w_T0177.n13 w_T0177.n40 4.54085
R346 w_T0177.n40 w_T0177.n14 4.54085
R347 w_T0177.n15 w_T0177.n22 4.54085
R348 w_T0177.n16 w_T0177.n17 9
R349 w_T0177.n16 w_T0177.n18 9
R350 w_T0177.n22 w_T0177.n19 4.54085
R351 w_T0177.n17 w_T0177.n20 0.0110476
R352 w_T0177.n20 w_T0177.n21 4.49523
R353 w_T0177.n23 w_T0177.n29 4.54085
R354 w_T0177.n24 w_T0177.n25 9
R355 w_T0177.n24 w_T0177.n26 9
R356 w_T0177.n29 w_T0177.n27 4.54085
R357 w_T0177.n25 w_T0177.n28 0.0110476
R358 w_T0177.n29 w_T0177.n28 4.51283
R359 w_T0158 w_T0177.n14 15.189
R360 w_T0177.n11 w_T0177.n14 0.02112
R361 w_T0177.n12 w_T0177.n11 0.0110476
R362 w_T0177.n13 w_T0177.n10 0.02112
R363 w_T0177.n27 w_T0177.n13 1.25664
R364 w_T0177.n26 w_T0177.n27 0.02112
R365 w_T0177.n28 w_T0177.n26 0.0110476
R366 w_T0177.n23 w_T0177.n25 0.02112
R367 w_T0177.n19 w_T0177.n23 0.86064
R368 w_T0177.n18 w_T0177.n19 0.02112
R369 w_T0177.n20 w_T0177.n18 0.0110476
R370 w_T0177.n15 w_T0177.n17 0.02112
R371 w_T0177.n30 w_T0177.n15 11.216
R372 w_T0177.n32 w_T0177.n31 0.201685
R373 w_T0177.n33 w_T0177.n34 9
R374 w_T0177.n35 w_T0177.n36 9
R375 w_T0177.n32 w_T0177.n34 2.0099
R376 w_T0177.n34 w_T0177.n36 0.1056
R377 w_T0177.n36 w_T0177.n30 0.1056
R378 w_T0177.n35 w_T0177.n37 0.0720603
R379 w_T0177.n38 w_T0177.n33 9
R380 w_T0177.n39 w_T0177.n31 9
R381 w_T0174 w_T0177.n32 2.54138
R382 w_T0177.n31 w_T0177.n33 0.145655
R383 w_T0177.n33 w_T0177.n35 0.145655
R384 w_T0177.n37 w_T0177.n30 9.07344
R385 w_T0174 w_T0177.n39 0.0865574
R386 w_T0177.n39 w_T0177.n38 0.173115
R387 w_T0177.n38 w_T0177.n37 4.68036
R388 w_T0177.n29 w_T0177.n24 0.0176
R389 w_T0041 w_T0177.n24 13.5567
R390 w_T0177.n22 w_T0177.n16 0.0176
R391 w_T0177.n22 w_T0177.n21 0.0176
R392 w_T0177.n21 w_T0073 9.95735
R393 w_T0187 w_T0187.n0 21.071
R394 w_T0183 w_T0187.n0 20.4546
R395 w_T0125 w_T0187.n0 21.8987
R396 w_T0195 w_T0195.n0 21.071
R397 w_T0175 w_T0195.n0 20.4546
R398 w_T0113 w_T0195.n0 21.8987
R399 w_T0179 w_T0179.n0 20.4546
R400 w_T0155 w_T0179.n0 21.0708
R401 w_T0129 w_T0179.n0 21.8987
R402 w_T0189 w_T0189.n0 17.9057
R403 w_T0159 w_T0189.n0 16.0546
R404 w_T0135 w_T0189.n0 16.6708
R405 VCTRL w_P005.n0 18.7
R406 w_P005.n1 w_P005.n0 0.396
R407 w_P005.n2 w_P005.n1 0.396
R408 w_T0015 w_P005.n2 38.4384
R409 w_T0007 w_P005.n2 38.2624
R410 w_T0011 w_P005.n1 38.4824
R411 w_T0003 w_P005.n0 38.7024
R412 w_T0130 w_T0130.n0 38.1325
R413 w_T0130.n1 w_T0130.n0 3.96
R414 w_T0130.n2 w_T0130.n1 5.148
R415 w_T0130.n3 w_T0130.n2 0.396
R416 w_T0130.n4 w_T0130.n3 0.396
R417 w_T0130.n5 w_T0130.n4 0.396
R418 w_T0130.n6 w_T0130.n5 0.264
R419 w_T0130.n7 w_T0130.n8 9
R420 w_T0130.n10 w_T0130.n9 0.118709
R421 w_T0130.n10 w_T0130.n8 3.12988
R422 w_T0130.n8 w_T0130.n6 29.8135
R423 w_T0130.n11 w_T0130.n7 9
R424 w_T0130.n12 w_T0130.n9 9
R425 w_T0023 w_T0130.n10 4.69214
R426 w_T0130.n9 w_T0130.n7 0.145655
R427 w_T0023 w_T0130.n12 0.0865574
R428 w_T0130.n12 w_T0130.n11 0.173115
R429 w_T0130.n14 w_T0130.n15 9
R430 w_T0130.n16 w_T0130.n17 9
R431 w_T0022 w_T0130.n14 0.0865574
R432 w_T0130.n16 w_T0130.n14 0.173115
R433 w_T0130.n11 w_T0130.n16 3.34089
R434 w_T0130.n15 w_T0130.n13 0.118703
R435 w_T0130.n17 w_T0130.n18 9
R436 w_T0022 w_T0130.n13 4.69139
R437 w_T0130.n17 w_T0130.n15 0.145655
R438 w_T0130.n13 w_T0130.n18 3.13021
R439 w_T0130.n18 w_T0130.n6 28.8491
R440 w_T0016 w_T0130.n5 48.648
R441 w_T0008 w_T0130.n4 48.868
R442 w_T0012 w_T0130.n3 49.088
R443 w_T0004 w_T0130.n2 49.308
R444 w_T0126 w_T0130.n1 34.1725
R445 w_T0114 w_T0130.n0 34.1725
R446 w_T0157 w_T0157.n1 21.9566
R447 w_T0157.n0 w_T0157.n1 3.564
R448 w_T0157.n2 w_T0157.n0 4.356
R449 w_T0157.n3 w_T0157.n2 4.356
R450 w_T0098 w_T0157.n3 23.6448
R451 w_T0110 w_T0157.n3 18.2328
R452 w_T0118 w_T0157.n2 18.2328
R453 w_T0087 w_T0157.n1 20.7437
R454 w_T0122 w_T0157.n0 18.2327
R455 w_T0133.n1 w_T0133 23.669
R456 w_T0133.n0 w_T0133.n1 3.564
R457 w_T0133.n2 w_T0133.n0 4.356
R458 w_T0133.n3 w_T0133.n2 4.356
R459 w_T0106 w_T0133.n3 25.5515
R460 w_T0102 w_T0133.n3 20.1395
R461 w_T0090 w_T0133.n2 20.1395
R462 w_T0084 w_T0133.n1 22.2837
R463 w_T0094 w_T0133.n0 20.1394
R464 w_P000.n25 w_P000.n24 2.2
R465 w_P000.n27 w_P000.n26 2.2
R466 w_P000.n29 w_P000.n28 2.2
R467 w_P000.n31 w_P000.n30 2.2
R468 w_P000.n33 w_P000.n32 2.2
R469 w_P000.n35 w_P000.n34 2.2
R470 w_P000.n37 w_P000.n36 2.2
R471 w_P000.n39 w_P000.n38 2.2
R472 w_P000.n41 w_P000.n40 2.2
R473 w_P000.n43 w_P000.n42 2.2
R474 w_P000.n45 w_P000.n44 2.2
R475 w_P000.n47 w_P000.n46 2.2
R476 w_P000.n49 w_P000.n48 2.2
R477 w_P000.n51 w_P000.n50 2.2
R478 w_P000.n53 w_P000.n52 2.2
R479 w_P000.n55 w_P000.n54 2.2
R480 w_P000.n57 w_P000.n56 2.2
R481 w_P000.n59 w_P000.n58 2.2
R482 w_P000.n61 w_P000.n60 2.2
R483 w_P000.n63 w_P000.n62 2.2
R484 w_P000.n0 AVDD 2.2
R485 w_P000.n0 w_P000.n1 3.784
R486 w_P000.n62 w_P000.n1 0.033
R487 w_P000.n62 w_P000.n2 0.363
R488 w_P000.n60 w_P000.n2 0.033
R489 w_P000.n60 w_P000.n3 1.551
R490 w_P000.n58 w_P000.n3 0.033
R491 w_P000.n58 w_P000.n4 0.363
R492 w_P000.n56 w_P000.n4 0.033
R493 w_P000.n56 w_P000.n5 1.155
R494 w_P000.n54 w_P000.n5 0.033
R495 w_P000.n54 w_P000.n6 0.363
R496 w_P000.n52 w_P000.n6 0.033
R497 w_P000.n52 w_P000.n7 1.947
R498 w_P000.n50 w_P000.n7 0.033
R499 w_P000.n50 w_P000.n8 0.363
R500 w_P000.n48 w_P000.n8 0.033
R501 w_P000.n48 w_P000.n9 1.551
R502 w_P000.n46 w_P000.n9 0.033
R503 w_P000.n46 w_P000.n10 0.363
R504 w_P000.n44 w_P000.n10 0.033
R505 w_P000.n44 w_P000.n11 1.551
R506 w_P000.n42 w_P000.n11 0.033
R507 w_P000.n42 w_P000.n12 0.363
R508 w_P000.n40 w_P000.n12 0.033
R509 w_P000.n40 w_P000.n13 1.947
R510 w_P000.n38 w_P000.n13 0.033
R511 w_P000.n38 w_P000.n14 0.363
R512 w_P000.n36 w_P000.n14 0.033
R513 w_P000.n36 w_P000.n15 1.463
R514 w_P000.n34 w_P000.n15 0.033
R515 w_P000.n34 w_P000.n16 0.451
R516 w_P000.n32 w_P000.n16 0.033
R517 w_P000.n32 w_P000.n17 0.363
R518 w_P000.n30 w_P000.n17 0.033
R519 w_P000.n30 w_P000.n18 0.363
R520 w_P000.n28 w_P000.n18 0.033
R521 w_P000.n28 w_P000.n19 0.363
R522 w_P000.n26 w_P000.n19 0.033
R523 w_P000.n26 w_P000.n20 0.759
R524 w_P000.n24 w_P000.n20 0.033
R525 w_P000.n24 w_P000.n21 1.023
R526 w_P000.n22 w_P000.n21 0.732086
R527 w_P000.n22 w_T0105 19.4747
R528 AVDD w_P000.n63 0.0975937
R529 w_P000.n63 w_P000.n61 0.010125
R530 w_P000.n61 w_P000.n59 0.0405
R531 w_P000.n59 w_P000.n57 0.010125
R532 w_P000.n57 w_P000.n55 0.030375
R533 w_P000.n55 w_P000.n53 0.010125
R534 w_P000.n53 w_P000.n51 0.050625
R535 w_P000.n51 w_P000.n49 0.010125
R536 w_P000.n49 w_P000.n47 0.0405
R537 w_P000.n47 w_P000.n45 0.010125
R538 w_P000.n45 w_P000.n43 0.0405
R539 w_P000.n43 w_P000.n41 0.010125
R540 w_P000.n41 w_P000.n39 0.050625
R541 w_P000.n39 w_P000.n37 0.010125
R542 w_P000.n37 w_P000.n35 0.03825
R543 w_P000.n35 w_P000.n33 0.012375
R544 w_P000.n33 w_P000.n31 0.010125
R545 w_P000.n31 w_P000.n29 0.010125
R546 w_P000.n29 w_P000.n27 0.010125
R547 w_P000.n27 w_P000.n25 0.02025
R548 w_P000.n25 w_P000.n23 0.027
R549 w_P000.n23 w_P000.n84 14.4655
R550 w_T0097 w_P000.n84 12.0226
R551 w_P000.n84 w_P000.n21 18.6892
R552 w_P000.n25 w_P000.n83 14.364
R553 w_T0026 w_P000.n83 23.434
R554 w_P000.n83 w_P000.n20 17.3369
R555 w_P000.n27 w_P000.n82 14.6815
R556 w_P000.n82 w_T0014 34.4871
R557 w_P000.n82 w_P000.n19 21.5697
R558 w_P000.n29 w_P000.n81 14.8465
R559 w_P000.n81 w_T0006 32.5071
R560 w_P000.n81 w_P000.n18 23.7697
R561 w_P000.n31 w_P000.n80 15.0115
R562 w_P000.n80 w_T0010 30.5271
R563 w_P000.n80 w_P000.n17 25.9697
R564 w_P000.n33 w_P000.n79 15.1765
R565 w_P000.n79 w_T0002 28.5471
R566 w_P000.n79 w_P000.n16 28.1697
R567 w_P000.n35 w_P000.n78 15.1655
R568 w_T0000 w_P000.n78 6.40562
R569 w_P000.n78 w_P000.n15 28.0231
R570 w_P000.n37 w_P000.n77 14.3005
R571 w_T0101 w_P000.n77 12.0226
R572 w_P000.n77 w_P000.n14 16.4892
R573 w_P000.n39 w_P000.n76 14.4655
R574 w_T0109 w_P000.n76 12.0226
R575 w_P000.n76 w_P000.n13 18.6892
R576 w_P000.n41 w_P000.n75 15.024
R577 w_T0043 w_P000.n75 12.874
R578 w_P000.n75 w_P000.n12 26.1369
R579 w_P000.n43 w_P000.n74 15.189
R580 w_T0031 w_P000.n74 12.214
R581 w_P000.n74 w_P000.n11 28.3369
R582 w_P000.n45 w_P000.n73 14.3005
R583 w_T0089 w_P000.n73 12.0226
R584 w_P000.n73 w_P000.n10 16.4892
R585 w_P000.n47 w_P000.n72 14.4655
R586 w_T0117 w_P000.n72 12.0226
R587 w_P000.n72 w_P000.n9 18.6892
R588 w_P000.n49 w_P000.n71 15.024
R589 w_T0034 w_P000.n71 12.874
R590 w_P000.n71 w_P000.n8 26.1369
R591 w_P000.n51 w_P000.n70 15.189
R592 w_T0037 w_P000.n70 12.214
R593 w_P000.n70 w_P000.n7 28.3369
R594 w_P000.n53 w_P000.n69 14.3005
R595 w_T0093 w_P000.n69 12.0225
R596 w_P000.n69 w_P000.n6 16.4892
R597 w_P000.n55 w_P000.n68 14.4655
R598 w_T0121 w_P000.n68 12.0226
R599 w_P000.n68 w_P000.n5 18.6892
R600 w_P000.n57 w_P000.n67 15.024
R601 w_T0040 w_P000.n67 12.874
R602 w_P000.n67 w_P000.n4 26.1369
R603 w_P000.n59 w_P000.n66 15.189
R604 w_T0046 w_P000.n66 12.214
R605 w_P000.n66 w_P000.n3 28.3369
R606 w_P000.n61 w_P000.n65 14.6665
R607 w_T0083 w_P000.n65 16.394
R608 w_P000.n65 w_P000.n2 21.3703
R609 w_P000.n63 w_P000.n64 14.7215
R610 w_T0086 w_P000.n64 14.414
R611 w_P000.n64 w_P000.n1 22.1036
R612 w_P000.n23 w_P000.n22 0.462424
R613 w_P003.n1 w_P003.n0 3.828
R614 w_P003.n2 w_P003.n1 3.3
R615 w_P003.n3 w_P003.n2 1.056
R616 w_P003.n4 w_P003.n3 0.528
R617 w_P003.n5 w_P003.n4 4.884
R618 w_P003.n6 w_P003.n5 0.528
R619 w_P003.n6 CLKP 2.288
R620 w_T0149 w_P003.n6 17.9527
R621 w_T0099 w_P003.n5 21.0745
R622 w_T0145 w_P003.n4 17.9527
R623 w_T0111 w_P003.n3 21.0745
R624 w_T0141 w_P003.n2 17.9527
R625 w_T0119 w_P003.n1 21.0745
R626 w_T0137 w_P003.n0 17.9526
R627 w_T0123 w_P003.n0 21.6025
R628 w_T0198 w_T0198.n9 18.9595
R629 w_T0198.n1 w_T0198.n0 3.168
R630 w_T0198.n2 w_T0198.n1 3.96
R631 w_T0198.n9 w_T0198.n2 0.396
R632 w_T0198.n3 w_T0198.n9 1.188
R633 w_T0198.n4 w_T0198.n3 0.396
R634 w_T0198.n5 w_T0198.n4 3.168
R635 w_T0198.n6 w_T0198.n5 0.264
R636 w_T0198.n7 w_T0198.n6 0.132
R637 w_T0198.n8 w_T0198.n7 1.452
R638 w_T0170 w_T0198.n8 19.3555
R639 w_T0150 w_T0198.n8 19.6929
R640 w_T0019 w_T0198.n7 33.6097
R641 w_T0018 w_T0198.n6 32.7774
R642 w_T0027 w_T0198.n5 32.961
R643 w_T0166 w_T0198.n4 18.9595
R644 w_T0146 w_T0198.n3 19.6929
R645 w_T0142 w_T0198.n2 19.6929
R646 w_T0162 w_T0198.n1 18.9595
R647 w_T0138 w_T0198.n0 19.6929
R648 w_T0190 w_T0198.n0 34.6382
R649 w_P001.n0 AVSS 2.2
R650 w_P001.n22 w_P001.n21 2.2
R651 w_P001.n24 w_P001.n23 2.2
R652 w_P001.n26 w_P001.n25 2.2
R653 w_P001.n28 w_P001.n27 2.2
R654 w_P001.n30 w_P001.n29 2.2
R655 w_P001.n32 w_P001.n31 2.2
R656 w_P001.n34 w_P001.n33 2.2
R657 w_P001.n36 w_P001.n35 2.2
R658 w_P001.n38 w_P001.n37 2.2
R659 w_P001.n40 w_P001.n39 2.2
R660 w_P001.n42 w_P001.n41 2.2
R661 w_P001.n44 w_P001.n43 2.2
R662 w_P001.n46 w_P001.n45 2.2
R663 w_P001.n48 w_P001.n47 2.2
R664 w_P001.n50 w_P001.n49 2.2
R665 w_P001.n52 w_P001.n51 2.2
R666 w_P001.n54 w_P001.n53 2.2
R667 w_P001.n56 w_P001.n55 2.2
R668 w_P001.n58 w_P001.n57 2.2
R669 w_P001.n134 w_P001.n59 0.55
R670 w_P001.n0 w_P001.n59 0.132
R671 w_P001.n59 w_P001.n57 3.487
R672 w_P001.n57 w_P001.n1 0.033
R673 w_P001.n1 w_P001.n55 1.947
R674 w_P001.n55 w_P001.n2 0.033
R675 w_P001.n2 w_P001.n53 1.023
R676 w_P001.n53 w_P001.n3 0.033
R677 w_P001.n3 w_P001.n51 0.363
R678 w_P001.n51 w_P001.n4 0.033
R679 w_P001.n4 w_P001.n49 1.287
R680 w_P001.n49 w_P001.n5 0.033
R681 w_P001.n5 w_P001.n47 1.155
R682 w_P001.n47 w_P001.n6 0.033
R683 w_P001.n6 w_P001.n45 1.023
R684 w_P001.n45 w_P001.n7 0.033
R685 w_P001.n7 w_P001.n43 0.363
R686 w_P001.n43 w_P001.n8 0.033
R687 w_P001.n8 w_P001.n41 0.495
R688 w_P001.n41 w_P001.n9 0.033
R689 w_P001.n9 w_P001.n39 1.947
R690 w_P001.n39 w_P001.n10 0.033
R691 w_P001.n10 w_P001.n37 1.023
R692 w_P001.n37 w_P001.n11 0.033
R693 w_P001.n11 w_P001.n35 0.363
R694 w_P001.n35 w_P001.n12 0.033
R695 w_P001.n12 w_P001.n33 0.495
R696 w_P001.n33 w_P001.n13 0.033
R697 w_P001.n13 w_P001.n31 0.363
R698 w_P001.n31 w_P001.n14 0.033
R699 w_P001.n14 w_P001.n29 1.155
R700 w_P001.n29 w_P001.n15 0.033
R701 w_P001.n15 w_P001.n27 0.363
R702 w_P001.n27 w_P001.n16 0.033
R703 w_P001.n16 w_P001.n25 2.739
R704 w_P001.n25 w_P001.n17 0.033
R705 w_P001.n17 w_P001.n23 0.759
R706 w_P001.n23 w_P001.n18 0.033
R707 w_P001.n18 w_P001.n21 1.419
R708 w_P001.n21 w_P001.n19 0.033
R709 w_P001.n19 w_P001.n20 1.44414
R710 w_P001.n62 w_P001.n61 0.55125
R711 w_P001.n60 w_P001.n61 0.5505
R712 AVSS w_P001.n60 0.0022725
R713 w_P001.n60 w_P001.n134 0.0011025
R714 w_P001.n134 w_P001.n62 0.0011025
R715 w_P001.n62 w_P001.n58 0.0880537
R716 w_P001.n58 w_P001.n56 0.050625
R717 w_P001.n56 w_P001.n54 0.027
R718 w_P001.n54 w_P001.n52 0.010125
R719 w_P001.n52 w_P001.n50 0.03375
R720 w_P001.n50 w_P001.n48 0.030375
R721 w_P001.n48 w_P001.n46 0.027
R722 w_P001.n46 w_P001.n44 0.010125
R723 w_P001.n44 w_P001.n42 0.0135
R724 w_P001.n42 w_P001.n40 0.050625
R725 w_P001.n40 w_P001.n38 0.027
R726 w_P001.n38 w_P001.n36 0.010125
R727 w_P001.n36 w_P001.n34 0.0135
R728 w_P001.n34 w_P001.n32 0.010125
R729 w_P001.n32 w_P001.n30 0.030375
R730 w_P001.n30 w_P001.n28 0.010125
R731 w_P001.n28 w_P001.n26 0.070875
R732 w_P001.n26 w_P001.n24 0.02025
R733 w_P001.n24 w_P001.n22 0.037125
R734 w_P001.n22 w_P001.n133 14.3076
R735 w_T0151 w_P001.n133 11.4638
R736 w_P001.n133 w_P001.n19 16.5838
R737 w_P001.n24 w_P001.n132 14.3626
R738 w_T0020 w_P001.n132 24.6481
R739 w_P001.n132 w_P001.n18 17.3171
R740 w_P001.n26 w_P001.n131 14.6926
R741 w_P001.n75 w_P001.n131 20.6736
R742 w_P001.n79 w_P001.n75 0.425186
R743 w_P001.n75 w_T0024 0.0146765
R744 w_P001.n76 w_P001.n81 0.0280098
R745 w_P001.n77 w_P001.n78 4.5
R746 w_P001.n79 w_P001.n80 4.5
R747 w_P001.n84 w_P001.n81 4.55636
R748 w_P001.n81 w_P001.n77 2.26847
R749 w_P001.n77 w_P001.n79 0.02112
R750 w_P001.n82 w_P001.n76 4.5
R751 w_P001.n83 w_P001.n78 4.5
R752 w_P001.n76 w_P001.n78 0.0548571
R753 w_P001.n78 w_P001.n80 0.0548571
R754 w_P001.n84 w_P001.n82 0.0276756
R755 w_P001.n85 w_P001.n83 0.0276756
R756 w_P001.n82 w_P001.n83 0.0548571
R757 w_P001.n85 w_P001.n80 4.52785
R758 w_P001.n86 w_P001.n84 2.25854
R759 w_P001.n86 w_P001.n85 2.25854
R760 w_P001.n89 w_P001.n86 0.815632
R761 w_P001.n87 w_P001.n88 0.264232
R762 w_P001.n88 w_P001.n89 0.203482
R763 w_P001.n89 w_P001.n118 1.28111
R764 w_P001.n120 w_P001.n121 0.0275982
R765 w_P001.n119 w_P001.n122 0.0275982
R766 w_P001.n118 w_P001.n119 2.27793
R767 w_P001.n118 w_P001.n120 2.27793
R768 w_P001.n121 w_P001.n124 4.5
R769 w_P001.n122 w_P001.n125 4.5
R770 w_P001.n120 w_P001.n123 4.52793
R771 w_P001.n121 w_P001.n122 0.0548571
R772 w_P001.n119 w_P001.n127 4.52793
R773 w_P001.n127 w_P001.n126 0.0278879
R774 w_P001.n128 w_P001.n124 4.5
R775 w_P001.n123 w_P001.n129 2.12697
R776 w_P001.n123 w_P001.n124 0.0548571
R777 w_P001.n124 w_P001.n125 0.0548571
R778 w_P001.n125 w_P001.n126 0.0276384
R779 w_P001.n127 w_P001.n130 12.156
R780 w_P001.n130 w_P001.n10 25.0168
R781 w_P001.n40 w_P001.n130 14.94
R782 w_T0127 w_P001.n129 0.367372
R783 w_P001.n129 w_P001.n128 0.358486
R784 w_P001.n126 w_P001.n128 2.26828
R785 w_P001.n88 w_P001.n105 1.28111
R786 w_P001.n107 w_P001.n108 0.0275982
R787 w_P001.n106 w_P001.n109 0.0275982
R788 w_P001.n105 w_P001.n106 2.27793
R789 w_P001.n105 w_P001.n107 2.27793
R790 w_P001.n108 w_P001.n111 4.5
R791 w_P001.n109 w_P001.n112 4.5
R792 w_P001.n107 w_P001.n110 4.52793
R793 w_P001.n108 w_P001.n109 0.0548571
R794 w_P001.n106 w_P001.n113 4.52793
R795 w_P001.n112 w_P001.n114 0.0275982
R796 w_P001.n115 w_P001.n111 4.5
R797 w_P001.n110 w_P001.n116 2.09982
R798 w_P001.n110 w_P001.n111 0.0548571
R799 w_P001.n111 w_P001.n112 0.0548571
R800 w_P001.n114 w_P001.n113 0.0279286
R801 w_P001.n113 w_P001.n117 12.156
R802 w_P001.n117 w_P001.n6 25.0168
R803 w_P001.n48 w_P001.n117 14.94
R804 w_T0115 w_P001.n116 0.422885
R805 w_P001.n116 w_P001.n115 0.445391
R806 w_P001.n114 w_P001.n115 2.30536
R807 w_P001.n87 w_P001.n90 1.28111
R808 w_P001.n91 w_P001.n92 0.0275982
R809 w_P001.n94 w_P001.n93 0.0279694
R810 w_P001.n94 w_P001.n99 4.52855
R811 w_P001.n90 w_P001.n94 2.27812
R812 w_P001.n90 w_P001.n91 2.27793
R813 w_P001.n92 w_P001.n97 4.5
R814 w_P001.n93 w_P001.n98 4.5
R815 w_P001.n91 w_P001.n95 4.52793
R816 w_P001.n92 w_P001.n93 0.0548571
R817 w_P001.n95 w_P001.n96 0.0278879
R818 w_P001.n100 w_P001.n98 4.5
R819 w_P001.n101 w_P001.n99 4.5
R820 w_P001.n96 w_P001.n97 0.0276384
R821 w_P001.n97 w_P001.n98 0.0548571
R822 w_P001.n98 w_P001.n99 0.0548571
R823 w_P001.n99 w_P001.n104 7.09601
R824 w_P001.n104 w_P001.n1 26.1168
R825 w_P001.n58 w_P001.n104 15.0225
R826 w_T0191 w_P001.n95 4.68054
R827 w_P001.n96 w_P001.n100 2.26828
R828 w_P001.n100 w_P001.n101 0.02112
R829 w_P001.n101 w_P001.n102 0.857725
R830 w_T0131 w_P001.n102 0.0139318
R831 w_P001.n102 w_P001.n103 17.2031
R832 w_P001.n103 w_P001.n2 25.0168
R833 w_P001.n56 w_P001.n103 14.94
R834 w_P001.n61 w_P001.n87 0.754344
R835 w_P001.n131 w_P001.n17 21.7171
R836 w_P001.n28 w_P001.n74 14.2526
R837 w_T0167 w_P001.n74 11.4638
R838 w_P001.n74 w_P001.n16 15.8505
R839 w_P001.n30 w_P001.n73 14.3076
R840 w_T0147 w_P001.n73 11.4638
R841 w_P001.n73 w_P001.n15 16.5838
R842 w_P001.n32 w_P001.n72 14.2526
R843 w_T0199 w_P001.n72 11.4638
R844 w_P001.n72 w_P001.n14 15.8505
R845 w_P001.n34 w_P001.n71 14.3076
R846 w_T0143 w_P001.n71 11.4638
R847 w_P001.n71 w_P001.n13 16.5838
R848 w_P001.n36 w_P001.n70 14.8272
R849 w_T0078 w_P001.n70 7.48974
R850 w_P001.n70 w_P001.n12 23.5131
R851 w_P001.n38 w_P001.n69 14.9923
R852 w_T0076 w_P001.n69 6.82974
R853 w_P001.n69 w_P001.n11 25.7131
R854 w_P001.n42 w_P001.n68 14.2526
R855 w_T0163 w_P001.n68 11.4638
R856 w_P001.n68 w_P001.n9 15.8505
R857 w_P001.n44 w_P001.n67 14.8272
R858 w_T0080 w_P001.n67 7.48974
R859 w_P001.n67 w_P001.n8 23.5131
R860 w_P001.n46 w_P001.n66 14.9923
R861 w_T0082 w_P001.n66 6.82974
R862 w_P001.n66 w_P001.n7 25.7131
R863 w_P001.n50 w_P001.n65 14.3076
R864 w_T0139 w_P001.n65 11.4638
R865 w_P001.n65 w_P001.n5 16.5838
R866 w_P001.n52 w_P001.n64 14.8272
R867 w_T0074 w_P001.n64 7.48974
R868 w_P001.n64 w_P001.n4 23.5131
R869 w_P001.n54 w_P001.n63 14.9923
R870 w_T0030 w_P001.n63 6.8158
R871 w_P001.n63 w_P001.n3 25.7131
R872 w_P001.n22 w_P001.n20 0.980305
R873 w_T0171 w_P001.n20 18.4652
R874 w_P002.n1 w_P002.n0 1.056
R875 w_P002.n2 w_P002.n1 3.3
R876 w_P002.n3 w_P002.n2 1.056
R877 w_P002.n4 w_P002.n3 0.528
R878 w_P002.n5 w_P002.n4 4.884
R879 w_P002.n6 w_P002.n5 0.528
R880 w_P002.n6 CLKN 1.892
R881 w_T0169 w_P002.n6 17.5127
R882 w_T0107 w_P002.n5 19.1678
R883 w_T0165 w_P002.n4 17.5127
R884 w_T0103 w_P002.n3 19.1678
R885 w_T0197 w_P002.n2 17.5127
R886 w_T0091 w_P002.n1 19.1678
R887 w_T0161 w_P002.n0 17.5126
R888 w_T0095 w_P002.n0 22.4678
C0 AVDD w_T0194 2.2218601074218749e-15
C1 AVDD w_T0177 2.911780029296875e-15
C2 w_T0193 w_T0130 4.6926399230957037e-17
C3 CLKN w_T0133 7.3941801757812513e-15
C4 w_T0194 w_T0133 3.3662600708007814e-16
C5 w_T0177 w_T0133 9.4819602966308602e-17
C6 w_T0185 w_T0195 4.2111700439453128e-16
C7 AVDD w_T0181 5.3420097656250005e-15
C8 w_T0198 CLKP 7.4938901367187504e-15
C9 AVDD CLKP 2.6060900390625004e-14
C10 w_T0194 w_T0177 5.9924499511718759e-16
C11 w_T0189 AVSS 2.105989990234375e-15
C12 w_T0182 w_T0193 5.6504400634765632e-16
C13 CLKP w_T0133 1.7584699707031251e-15
C14 AVDD w_T0185 3.5573000488281247e-15
C15 AVSS w_T0130 5.6656199218750004e-14
C16 w_T0181 w_T0194 4.2979299926757818e-16
C17 w_T0181 w_T0177 1.9278000488281253e-15
C18 AVDD w_T0187 3.9387001037597662e-17
C19 CLKP CLKN 1.6119099609374999e-14
C20 w_T0198 w_T0179 1.1897399425506594e-18
C21 w_T0193 w_T0195 2.247219970703125e-15
C22 w_T0198 SUB 3.8594201207160954e-19
C23 w_T0198 w_T0157 6.9639801025390632e-16
C24 AVDD w_T0179 3.9387001037597662e-17
C25 VCTRL w_T0198 1.4283299804687502e-14
C26 AVDD SUB 1.4592799804687501e-14
C27 AVDD w_T0157 9.1153896484375001e-15
C28 VCTRL AVDD 2.9155400390625001e-14
C29 w_T0182 AVSS 9.8472197265624999e-15
C30 w_T0185 w_T0194 1.9283900146484376e-15
C31 SUB w_T0133 8.2649499511718759e-16
C32 w_T0157 w_T0133 1.4456400390625001e-14
C33 w_T0182 w_T0130 3.184210014343262e-17
C34 VCTRL w_T0133 1.5726099853515627e-15
C35 AVDD w_T0193 2.3171799316406251e-15
C36 w_T0194 w_T0179 2.2006201171875001e-15
C37 w_T0181 w_T0185 5.4960797119140631e-16
C38 w_T0177 w_T0179 3.376610107421875e-15
C39 SUB w_T0194 6.3777500391006473e-19
C40 SUB w_T0177 3.8594201207160954e-19
C41 w_T0187 w_T0181 3.82589990234375e-15
C42 VCTRL CLKN 8.6911601562499996e-15
C43 AVSS w_T0195 3.8376899414062505e-15
C44 w_T0157 w_T0177 3.1737399291992189e-16
C45 w_T0195 w_T0130 3.3179299926757811e-16
C46 w_T0181 w_T0179 4.1464199218750001e-15
C47 w_T0193 w_T0194 8.8557897949218753e-16
C48 w_T0189 w_T0198 2.9391598510742194e-16
C49 w_T0198 AVSS 5.1637000000000005e-14
C50 w_T0187 w_T0185 2.2575600585937505e-15
C51 AVDD AVSS 1.9823900000000002e-13
C52 w_T0157 CLKP 7.3941801757812513e-15
C53 VCTRL CLKP 1.6391899414062502e-15
C54 w_T0198 w_T0130 1.4877200195312501e-14
C55 w_T0189 w_T0133 1.3434000244140626e-15
C56 w_T0181 w_T0193 4.2099099731445314e-16
C57 w_T0182 w_T0195 3.1370100097656252e-15
C58 AVDD w_T0130 4.1166898437500005e-14
C59 AVSS w_T0133 9.0766201171875014e-15
C60 w_T0185 w_T0179 3.3370200195312501e-15
C61 w_T0130 w_T0133 2.9816499023437502e-15
C62 w_T0189 w_T0194 1.7195699462890627e-15
C63 w_T0189 w_T0177 2.2939099121093753e-15
C64 AVSS CLKN 1.6061599609375002e-14
C65 AVSS w_T0194 8.2563095703125005e-15
C66 AVSS w_T0177 9.8472197265624999e-15
C67 w_T0185 w_T0193 3.7828999023437499e-15
C68 w_T0130 CLKN 3.0831398925781251e-15
C69 w_T0187 w_T0193 2.8324099121093752e-15
C70 w_T0182 AVDD 2.9951398925781252e-15
C71 w_T0194 w_T0130 4.8134700775146488e-17
C72 w_T0130 w_T0177 3.184210014343262e-17
C73 w_T0157 SUB 6.1487501859664923e-19
C74 VCTRL SUB 4.9763598632812499e-15
C75 VCTRL w_T0157 1.6130999755859376e-15
C76 w_T0181 AVSS 9.8472197265624999e-15
C77 CLKP AVSS 1.5850099609375001e-14
C78 w_T0181 w_T0130 3.184210014343262e-17
C79 AVDD w_T0195 3.9387001037597662e-17
C80 CLKP w_T0130 3.1452299804687499e-15
C81 w_T0182 w_T0177 8.7458099365234387e-16
C82 w_T0185 AVSS 8.2158896484375004e-15
C83 w_T0187 AVSS 3.8376899414062505e-15
C84 w_T0198 AVDD 1.7274400390625002e-14
C85 w_T0185 w_T0130 4.6926399230957037e-17
C86 w_T0182 w_T0181 3.7673300781250003e-15
C87 w_T0187 w_T0130 3.3179299926757811e-16
C88 w_T0189 w_T0179 1.3613100051879882e-18
C89 w_T0189 SUB 6.5148000717163088e-18
C90 w_T0195 w_T0194 2.7223500976562502e-15
C91 w_T0195 w_T0177 3.7530100097656253e-15
C92 AVSS w_T0179 3.4928500976562504e-15
C93 w_T0189 w_T0157 2.4748898925781251e-15
C94 w_T0198 w_T0133 6.5428100585937508e-16
C95 SUB AVSS 2.3323800781250003e-14
C96 w_T0157 AVSS 9.5324296875000014e-15
C97 VCTRL AVSS 9.3092500000000011e-15
C98 AVDD w_T0133 8.9577802734375002e-15
C99 w_T0130 w_T0179 3.3179299926757811e-16
C100 w_T0198 CLKN 7.7866298828125006e-15
C101 w_T0157 w_T0130 2.7812700195312505e-15
C102 w_T0181 w_T0195 1.0303499755859376e-15
C103 VCTRL w_T0130 2.7659099609375003e-14
C104 w_T0182 w_T0187 3.8542600097656259e-15
C105 AVSS w_T0193 8.2158896484375004e-15
C106 AVDD CLKN 1.7785900390624999e-14
C107 SUB WIRE_CREF 2.4162327575683593e-16
C108 w_T0071 WIRE_CREF 6.3674780273437502e-15
C109 w_T0069 WIRE_CREF 6.3674780273437502e-15
C110 w_T0067 WIRE_CREF 6.3674780273437502e-15
C111 w_T0065 WIRE_CREF 6.3674780273437502e-15
C112 w_T0063 WIRE_CREF 6.3674780273437502e-15
C113 w_T0061 WIRE_CREF 6.3674780273437502e-15
C114 w_T0059 WIRE_CREF 6.3674780273437502e-15
C115 w_T0057 WIRE_CREF 6.3674780273437502e-15
C116 w_T0055 WIRE_CREF 6.3674780273437502e-15
C117 w_T0053 WIRE_CREF 6.3674780273437502e-15
C118 w_T0051 WIRE_CREF 6.3977075195312502e-15
C119 w_T0049 WIRE_CREF 6.3674780273437502e-15
C120 w_T0185 WIRE_CREF 2.7413785934448243e-17
C121 w_T0154 WIRE_CREF 1.9029016494750976e-17
C122 w_T0075 WIRE_CREF 6.5026469726562507e-15
C123 w_T0032 WIRE_CREF 2.3009951782226562e-16
C124 w_T0193 WIRE_CREF 2.8787225723266605e-17
C125 w_T0186 WIRE_CREF 1.9982376098632815e-17
C126 w_T0081 WIRE_CREF 6.5215522460937502e-15
C127 w_T0038 WIRE_CREF 2.2923060607910159e-16
C128 w_T0194 WIRE_CREF 2.0941640853881836e-17
C129 w_T0153 WIRE_CREF 3.0175844192504888e-17
C130 w_T0134 WIRE_CREF 4.2647311401367191e-16
C131 w_T0047 WIRE_CREF 2.3061877441406253e-16
C132 w_T0029 WIRE_CREF 6.8839897460937502e-15
C133 w_T0181 WIRE_CREF 2.6449924468994143e-17
C134 w_T0178 WIRE_CREF 1.8359960556030272e-17
C135 w_T0077 WIRE_CREF 6.9362231445312509e-15
C136 w_T0044 WIRE_CREF 2.4128683471679691e-16
C137 w_T0182 WIRE_CREF 2.0091588973999027e-17
C138 w_T0173 WIRE_CREF 2.8950962066650392e-17
C139 w_T0079 WIRE_CREF 7.2809013671875012e-15
C140 w_T0035 WIRE_CREF 2.5177325439453126e-16
C141 w_T0177 WIRE_CREF 3.0536291122436528e-17
C142 w_T0174 WIRE_CREF 2.1196472167968752e-17
C143 w_T0158 WIRE_CREF 4.6778375244140627e-16
C144 w_T0073 WIRE_CREF 7.7382465820312511e-15
C145 w_T0041 WIRE_CREF 2.5583396911621096e-16
C146 w_T0187 WIRE_CREF 1.8197187500000001e-15
C147 w_T0183 WIRE_CREF 1.2447032470703127e-15
C148 w_T0125 WIRE_CREF 7.181040649414063e-16
C149 w_T0195 WIRE_CREF 1.8566264648437501e-15
C150 w_T0175 WIRE_CREF 1.2699483642578126e-15
C151 w_T0113 WIRE_CREF 7.3266876220703132e-16
C152 w_T0179 WIRE_CREF 1.2621928710937501e-15
C153 w_T0155 WIRE_CREF 1.8452957763671877e-15
C154 w_T0129 WIRE_CREF 7.2819421386718759e-16
C155 w_T0189 WIRE_CREF 4.3050857543945319e-16
C156 w_T0159 WIRE_CREF 1.0364197998046877e-15
C157 w_T0135 WIRE_CREF 1.7208515625000003e-15
C158 VCTRL WIRE_CREF 9.7658574218749995e-15
C159 w_T0015 WIRE_CREF 1.0687456054687501e-15
C160 w_T0011 WIRE_CREF 1.5989831542968753e-15
C161 w_T0007 WIRE_CREF 1.2994735107421877e-15
C162 w_T0003 WIRE_CREF 1.9367421875e-15
C163 w_T0130 WIRE_CREF 3.1154714355468753e-15
C164 w_T0126 WIRE_CREF 2.3640646972656254e-15
C165 w_T0114 WIRE_CREF 2.3640646972656254e-15
C166 w_T0023 WIRE_CREF 9.9774141311645512e-18
C167 w_T0022 WIRE_CREF 9.620408058166504e-18
C168 w_T0016 WIRE_CREF 1.262131591796875e-15
C169 w_T0012 WIRE_CREF 1.8973374023437502e-15
C170 w_T0008 WIRE_CREF 1.5589169921875001e-15
C171 w_T0004 WIRE_CREF 2.2768356933593753e-15
C172 w_T0157 WIRE_CREF 1.2830906982421875e-15
C173 w_T0122 WIRE_CREF 4.0623037719726563e-16
C174 w_T0118 WIRE_CREF 4.0622903442382815e-16
C175 w_T0110 WIRE_CREF 4.0622903442382815e-16
C176 w_T0098 WIRE_CREF 1.4181376953125002e-15
C177 w_T0087 WIRE_CREF 4.9925527954101569e-16
C178 w_T0133 WIRE_CREF 2.1311821289062503e-15
C179 w_T0106 WIRE_CREF 1.9111019287109377e-15
C180 w_T0102 WIRE_CREF 7.6731652832031254e-16
C181 w_T0094 WIRE_CREF 7.6731872558593753e-16
C182 w_T0090 WIRE_CREF 7.6731652832031254e-16
C183 w_T0084 WIRE_CREF 5.2301031494140631e-16
C184 AVDD WIRE_CREF 1.5247704101562501e-14
C185 w_T0121 WIRE_CREF 1.3910871887207032e-16
C186 w_T0117 WIRE_CREF 1.3910871887207032e-16
C187 w_T0109 WIRE_CREF 1.3910871887207032e-16
C188 w_T0105 WIRE_CREF 1.5588657226562501e-15
C189 w_T0101 WIRE_CREF 1.3910871887207032e-16
C190 w_T0097 WIRE_CREF 1.3910871887207032e-16
C191 w_T0093 WIRE_CREF 1.3910925292968752e-16
C192 w_T0089 WIRE_CREF 1.3910871887207032e-16
C193 w_T0086 WIRE_CREF 1.6772846984863282e-16
C194 w_T0083 WIRE_CREF 2.0707579040527344e-16
C195 w_T0046 WIRE_CREF 1.2374642944335937e-16
C196 w_T0043 WIRE_CREF 1.3697804260253909e-16
C197 w_T0040 WIRE_CREF 1.3697804260253909e-16
C198 w_T0037 WIRE_CREF 1.2374642944335937e-16
C199 w_T0034 WIRE_CREF 1.3697804260253909e-16
C200 w_T0031 WIRE_CREF 1.2374642944335937e-16
C201 w_T0026 WIRE_CREF 3.0751980590820314e-16
C202 w_T0014 WIRE_CREF 1.4767535400390626e-16
C203 w_T0010 WIRE_CREF 9.5961494445800784e-17
C204 w_T0006 WIRE_CREF 1.2103881835937499e-16
C205 w_T0002 WIRE_CREF 7.2767791748046877e-17
C206 w_T0000 WIRE_CREF 7.2350471496582027e-17
C207 CLKP WIRE_CREF 1.4766785888671875e-15
C208 w_T0149 WIRE_CREF 3.4738186645507814e-16
C209 w_T0145 WIRE_CREF 3.4738186645507814e-16
C210 w_T0141 WIRE_CREF 3.4738186645507814e-16
C211 w_T0137 WIRE_CREF 3.4738305664062506e-16
C212 w_T0123 WIRE_CREF 1.5849802246093751e-15
C213 w_T0119 WIRE_CREF 1.5328568115234377e-15
C214 w_T0111 WIRE_CREF 1.5328568115234377e-15
C215 w_T0099 WIRE_CREF 1.5328568115234377e-15
C216 w_T0198 WIRE_CREF 4.2784613037109377e-16
C217 w_T0190 WIRE_CREF 3.2934685058593753e-15
C218 w_T0170 WIRE_CREF 4.4859823608398437e-16
C219 w_T0166 WIRE_CREF 4.2784451293945315e-16
C220 w_T0162 WIRE_CREF 4.2784591674804692e-16
C221 w_T0150 WIRE_CREF 5.4206951904296878e-16
C222 w_T0146 WIRE_CREF 5.4206951904296878e-16
C223 w_T0142 WIRE_CREF 5.4206951904296878e-16
C224 w_T0138 WIRE_CREF 5.4206951904296878e-16
C225 w_T0027 WIRE_CREF 1.0399184570312502e-15
C226 w_T0019 WIRE_CREF 8.9160144042968748e-16
C227 w_T0018 WIRE_CREF 8.5656365966796883e-16
C228 AVSS WIRE_CREF 6.5416424560546878e-16
C229 w_T0199 WIRE_CREF 2.6917135620117192e-16
C230 w_T0191 WIRE_CREF 1.8814042663574219e-16
C231 w_T0171 WIRE_CREF 1.5381070556640627e-15
C232 w_T0167 WIRE_CREF 2.6917135620117192e-16
C233 w_T0163 WIRE_CREF 2.6917135620117192e-16
C234 w_T0151 WIRE_CREF 2.6917135620117192e-16
C235 w_T0147 WIRE_CREF 2.6917135620117192e-16
C236 w_T0143 WIRE_CREF 2.6917135620117192e-16
C237 w_T0139 WIRE_CREF 2.6917135620117192e-16
C238 w_T0131 WIRE_CREF 1.699650573730469e-16
C239 w_T0127 WIRE_CREF 3.7271783447265631e-16
C240 w_T0115 WIRE_CREF 4.1141796875000001e-16
C241 w_T0082 WIRE_CREF 3.5852431640625004e-15
C242 w_T0080 WIRE_CREF 3.7448112792968748e-15
C243 w_T0078 WIRE_CREF 3.7448112792968748e-15
C244 w_T0076 WIRE_CREF 3.5852431640625004e-15
C245 w_T0074 WIRE_CREF 3.7448112792968748e-15
C246 w_T0030 WIRE_CREF 3.6310002441406252e-15
C247 w_T0024 WIRE_CREF 5.4163288116455084e-17
C248 w_T0020 WIRE_CREF 4.4753375244140628e-16
C249 CLKN WIRE_CREF 1.12716845703125e-15
C250 w_T0197 WIRE_CREF 2.6269100952148442e-16
C251 w_T0169 WIRE_CREF 2.6269100952148442e-16
C252 w_T0165 WIRE_CREF 2.6269100952148442e-16
C253 w_T0161 WIRE_CREF 2.6269192504882811e-16
C254 w_T0107 WIRE_CREF 1.1006295166015626e-15
C255 w_T0103 WIRE_CREF 1.1006295166015626e-15
C256 w_T0095 WIRE_CREF 1.5490949707031251e-15
C257 w_T0091 WIRE_CREF 1.1006295166015626e-15
C258 w_P002.n0 WIRE_CREF 5.4206118164062503e-15
C259 w_P002.n1 WIRE_CREF 3.6044055175781258e-15
C260 w_P002.n2 WIRE_CREF 2.8157324218750002e-15
C261 w_P002.n3 WIRE_CREF 2.0263699951171879e-15
C262 w_P002.n4 WIRE_CREF 3.4168889160156253e-15
C263 w_P002.n5 WIRE_CREF 4.2055620117187505e-15
C264 w_P002.n6 WIRE_CREF 1.7136121826171877e-15
C265 w_P001.n0 WIRE_CREF 1.0170464324951172e-16
C266 w_P001.n1 WIRE_CREF 3.8971037597656257e-15
C267 w_P001.n2 WIRE_CREF 3.2925129394531251e-15
C268 w_P001.n3 WIRE_CREF 3.0996569824218753e-15
C269 w_P001.n4 WIRE_CREF 3.1728635253906256e-15
C270 w_P001.n5 WIRE_CREF 2.0181333007812501e-15
C271 w_P001.n6 WIRE_CREF 3.2925129394531251e-15
C272 w_P001.n7 WIRE_CREF 3.0996569824218753e-15
C273 w_P001.n8 WIRE_CREF 2.8067268066406251e-15
C274 w_P001.n9 WIRE_CREF 2.2715659179687505e-15
C275 w_P001.n10 WIRE_CREF 3.2925129394531251e-15
C276 w_P001.n11 WIRE_CREF 3.0996569824218753e-15
C277 w_P001.n12 WIRE_CREF 2.8067268066406251e-15
C278 w_P001.n13 WIRE_CREF 1.6519967041015626e-15
C279 w_P001.n14 WIRE_CREF 1.9054290771484375e-15
C280 w_P001.n15 WIRE_CREF 1.6519967041015626e-15
C281 w_P001.n16 WIRE_CREF 2.6377026367187502e-15
C282 w_P001.n17 WIRE_CREF 2.6416594238281252e-15
C283 w_P001.n18 WIRE_CREF 2.2536745605468752e-15
C284 w_P001.n19 WIRE_CREF 2.8440522460937502e-15
C285 w_P001.n20 WIRE_CREF 2.5585217285156254e-15
C286 w_P001.n21 WIRE_CREF 6.7125061035156257e-16
C287 w_P001.n22 WIRE_CREF 2.0672990234375002e-14
C288 w_P001.n23 WIRE_CREF 3.6613671875000002e-16
C289 w_P001.n24 WIRE_CREF 1.4769535156250003e-14
C290 w_P001.n25 WIRE_CREF 1.281478515625e-15
C291 w_P001.n26 WIRE_CREF 2.1737697265625e-14
C292 w_P001.n27 WIRE_CREF 1.8306835937500001e-16
C293 w_P001.n28 WIRE_CREF 1.7482455078125002e-14
C294 w_P001.n29 WIRE_CREF 5.49205078125e-16
C295 w_P001.n30 WIRE_CREF 1.1977017578125001e-14
C296 w_P001.n31 WIRE_CREF 1.8306835937500001e-16
C297 w_P001.n32 WIRE_CREF 1.16242666015625e-14
C298 w_P001.n33 WIRE_CREF 2.4409114074707034e-16
C299 w_P001.n34 WIRE_CREF 9.5361054687500013e-15
C300 w_P001.n35 WIRE_CREF 1.8306835937500001e-16
C301 w_P001.n36 WIRE_CREF 1.2814548828125002e-14
C302 w_P001.n37 WIRE_CREF 4.8818228149414068e-16
C303 w_P001.n38 WIRE_CREF 1.5788496093750001e-14
C304 w_P001.n39 WIRE_CREF 9.1534179687499997e-16
C305 w_P001.n40 WIRE_CREF 2.1324449218750004e-14
C306 w_P001.n41 WIRE_CREF 2.4409114074707034e-16
C307 w_P001.n42 WIRE_CREF 1.5041542968750002e-14
C308 w_P001.n43 WIRE_CREF 1.8306835937500001e-16
C309 w_P001.n44 WIRE_CREF 1.2814548828125002e-14
C310 w_P001.n45 WIRE_CREF 4.8818228149414068e-16
C311 w_P001.n46 WIRE_CREF 1.5788496093750001e-14
C312 w_P001.n47 WIRE_CREF 5.49205078125e-16
C313 w_P001.n48 WIRE_CREF 1.8395355468750003e-14
C314 w_P001.n49 WIRE_CREF 6.1022784423828129e-16
C315 w_P001.n50 WIRE_CREF 1.5394292968749999e-14
C316 w_P001.n51 WIRE_CREF 1.8306835937500001e-16
C317 w_P001.n52 WIRE_CREF 1.5743642578125002e-14
C318 w_P001.n53 WIRE_CREF 4.8818228149414068e-16
C319 w_P001.n54 WIRE_CREF 1.5788496093750001e-14
C320 w_P001.n55 WIRE_CREF 9.1534179687499997e-16
C321 w_P001.n56 WIRE_CREF 2.1324449218750004e-14
C322 w_P001.n57 WIRE_CREF 1.6272742919921875e-15
C323 w_P001.n58 WIRE_CREF 3.0664316406249998e-14
C324 w_P001.n59 WIRE_CREF 1.6730413818359377e-15
C325 w_P001.n60 WIRE_CREF 4.89272705078125e-16
C326 w_P001.n61 WIRE_CREF 3.2296164062499999e-14
C327 w_P001.n62 WIRE_CREF 1.2897826171875002e-14
C328 w_P001.n63 WIRE_CREF 5.9218266601562505e-15
C329 w_P001.n64 WIRE_CREF 5.4053891601562499e-15
C330 w_P001.n65 WIRE_CREF 3.5291750488281254e-15
C331 w_P001.n66 WIRE_CREF 5.9228334960937503e-15
C332 w_P001.n67 WIRE_CREF 5.4053891601562499e-15
C333 w_P001.n68 WIRE_CREF 3.3437197265625002e-15
C334 w_P001.n69 WIRE_CREF 5.9228334960937503e-15
C335 w_P001.n70 WIRE_CREF 5.4053891601562499e-15
C336 w_P001.n71 WIRE_CREF 3.5291750488281254e-15
C337 w_P001.n72 WIRE_CREF 3.3437197265625002e-15
C338 w_P001.n73 WIRE_CREF 3.5291750488281254e-15
C339 w_P001.n74 WIRE_CREF 3.3437197265625002e-15
C340 w_P001.n75 WIRE_CREF 3.4578646850585937e-16
C341 w_P001.n76 WIRE_CREF 7.5180072784423841e-18
C342 w_P001.n77 WIRE_CREF 4.5289916992187501e-17
C343 w_P001.n78 WIRE_CREF 7.5180072784423841e-18
C344 w_P001.n79 WIRE_CREF 8.7598747253417981e-17
C345 w_P001.n80 WIRE_CREF 6.067533016204835e-18
C346 w_P001.n81 WIRE_CREF 6.3243517875671395e-18
C347 w_P001.n82 WIRE_CREF 7.5180072784423841e-18
C348 w_P001.n83 WIRE_CREF 7.5180072784423841e-18
C349 w_P001.n84 WIRE_CREF 6.2210226058959969e-18
C350 w_P001.n85 WIRE_CREF 6.1827206611633302e-18
C351 w_P001.n86 WIRE_CREF 3.5435358886718753e-15
C352 w_P001.n87 WIRE_CREF 3.2596701171875003e-14
C353 w_P001.n88 WIRE_CREF 2.1121851562500005e-14
C354 w_P001.n89 WIRE_CREF 2.8434343750000001e-14
C355 w_P001.n90 WIRE_CREF 1.8479031982421877e-15
C356 w_P001.n91 WIRE_CREF 6.2046771049499519e-18
C357 w_P001.n92 WIRE_CREF 7.5180072784423841e-18
C358 w_P001.n93 WIRE_CREF 7.5180072784423841e-18
C359 w_P001.n94 WIRE_CREF 6.2038278579711926e-18
C360 w_P001.n95 WIRE_CREF 7.6052772521972653e-17
C361 w_P001.n96 WIRE_CREF 2.4213016033172609e-19
C362 w_P001.n97 WIRE_CREF 7.5180072784423841e-18
C363 w_P001.n98 WIRE_CREF 7.5180072784423841e-18
C364 w_P001.n99 WIRE_CREF 8.0234413146972666e-17
C365 w_P001.n100 WIRE_CREF 4.5289894104003913e-17
C366 w_P001.n101 WIRE_CREF 2.9360894775390627e-16
C367 w_P001.n102 WIRE_CREF 4.4943951416015625e-16
C368 w_P001.n103 WIRE_CREF 6.1168017578124998e-15
C369 w_P001.n104 WIRE_CREF 5.9390341796875005e-15
C370 w_P001.n105 WIRE_CREF 1.8479031982421877e-15
C371 w_P001.n106 WIRE_CREF 6.2046771049499519e-18
C372 w_P001.n107 WIRE_CREF 6.2046771049499519e-18
C373 w_P001.n108 WIRE_CREF 7.5180072784423841e-18
C374 w_P001.n109 WIRE_CREF 7.5180072784423841e-18
C375 w_P001.n110 WIRE_CREF 7.6644416809082036e-17
C376 w_P001.n111 WIRE_CREF 7.5180072784423841e-18
C377 w_P001.n112 WIRE_CREF 7.5180072784423841e-18
C378 w_P001.n113 WIRE_CREF 2.0706564331054691e-16
C379 w_P001.n114 WIRE_CREF 3.2065525650978091e-19
C380 w_P001.n115 WIRE_CREF 2.0485693359375002e-16
C381 w_P001.n116 WIRE_CREF 3.4835685729980472e-17
C382 w_P001.n117 WIRE_CREF 6.0345800781250002e-15
C383 w_P001.n118 WIRE_CREF 1.8479031982421877e-15
C384 w_P001.n119 WIRE_CREF 6.2046771049499519e-18
C385 w_P001.n120 WIRE_CREF 6.2046771049499519e-18
C386 w_P001.n121 WIRE_CREF 7.5180072784423841e-18
C387 w_P001.n122 WIRE_CREF 7.5180072784423841e-18
C388 w_P001.n123 WIRE_CREF 7.6644416809082036e-17
C389 w_P001.n124 WIRE_CREF 7.5180072784423841e-18
C390 w_P001.n125 WIRE_CREF 7.5180072784423841e-18
C391 w_P001.n126 WIRE_CREF 2.4213016033172609e-19
C392 w_P001.n127 WIRE_CREF 2.0704603576660157e-16
C393 w_P001.n128 WIRE_CREF 2.5655337524414065e-16
C394 w_P001.n129 WIRE_CREF 2.1937591552734378e-17
C395 w_P001.n130 WIRE_CREF 6.0345800781250002e-15
C396 w_P001.n131 WIRE_CREF 4.9986235351562506e-15
C397 w_P001.n132 WIRE_CREF 3.9435354003906252e-15
C398 w_P001.n133 WIRE_CREF 3.5291750488281254e-15
C399 w_P001.n134 WIRE_CREF 3.1894577026367188e-16
C400 w_T0198.n0 WIRE_CREF 1.2532201171875002e-14
C401 w_T0198.n1 WIRE_CREF 5.5468320312500005e-15
C402 w_T0198.n2 WIRE_CREF 3.9017827148437499e-15
C403 w_T0198.n3 WIRE_CREF 2.0107624511718753e-15
C404 w_T0198.n4 WIRE_CREF 3.1155219726562503e-15
C405 w_T0198.n5 WIRE_CREF 4.4815620117187502e-15
C406 w_T0198.n6 WIRE_CREF 1.8308010253906253e-15
C407 w_T0198.n7 WIRE_CREF 2.7275859375000002e-15
C408 w_T0198.n8 WIRE_CREF 3.1844941406250001e-15
C409 w_T0198.n9 WIRE_CREF 1.7647918701171875e-15
C410 w_P003.n0 WIRE_CREF 5.2907661132812501e-15
C411 w_P003.n1 WIRE_CREF 6.1797631835937508e-15
C412 w_P003.n2 WIRE_CREF 3.2103212890625006e-15
C413 w_P003.n3 WIRE_CREF 2.7341794433593755e-15
C414 w_P003.n4 WIRE_CREF 3.8666228027343749e-15
C415 w_P003.n5 WIRE_CREF 5.1132724609375004e-15
C416 w_P003.n6 WIRE_CREF 2.2532145996093752e-15
C417 w_P000.n0 WIRE_CREF 1.8898563232421877e-15
C418 w_P000.n1 WIRE_CREF 4.3305332031250007e-15
C419 w_P000.n2 WIRE_CREF 2.5374367675781251e-15
C420 w_P000.n3 WIRE_CREF 4.3007211914062503e-15
C421 w_P000.n4 WIRE_CREF 3.3448178710937503e-15
C422 w_P000.n5 WIRE_CREF 2.4766394042968753e-15
C423 w_P000.n6 WIRE_CREF 1.7287535400390627e-15
C424 w_P000.n7 WIRE_CREF 4.4940014648437501e-15
C425 w_P000.n8 WIRE_CREF 3.3448178710937503e-15
C426 w_P000.n9 WIRE_CREF 2.6699201660156255e-15
C427 w_P000.n10 WIRE_CREF 1.7287535400390627e-15
C428 w_P000.n11 WIRE_CREF 4.3007211914062503e-15
C429 w_P000.n12 WIRE_CREF 3.3448178710937503e-15
C430 w_P000.n13 WIRE_CREF 2.8632009277343752e-15
C431 w_P000.n14 WIRE_CREF 1.7287535400390627e-15
C432 w_P000.n15 WIRE_CREF 4.2040175781250004e-15
C433 w_P000.n16 WIRE_CREF 3.7351918945312505e-15
C434 w_P000.n17 WIRE_CREF 3.3163100585937502e-15
C435 w_P000.n18 WIRE_CREF 2.94234765625e-15
C436 w_P000.n19 WIRE_CREF 2.5709550781250003e-15
C437 w_P000.n20 WIRE_CREF 2.0605061035156252e-15
C438 w_P000.n21 WIRE_CREF 3.8619216308593756e-15
C439 w_P000.n22 WIRE_CREF 2.8522187500000003e-15
C440 w_P000.n23 WIRE_CREF 2.1182011718750001e-14
C441 w_P000.n24 WIRE_CREF 5.1541534423828129e-16
C442 w_P000.n25 WIRE_CREF 1.4057208007812501e-14
C443 w_P000.n26 WIRE_CREF 3.8656152343750004e-16
C444 w_P000.n27 WIRE_CREF 1.3599724609375002e-14
C445 w_P000.n28 WIRE_CREF 1.9328076171875002e-16
C446 w_P000.n29 WIRE_CREF 1.31402734375e-14
C447 w_P000.n30 WIRE_CREF 1.9328076171875002e-16
C448 w_P000.n31 WIRE_CREF 1.4217341796875001e-14
C449 w_P000.n32 WIRE_CREF 1.9328076171875002e-16
C450 w_P000.n33 WIRE_CREF 1.56286083984375e-14
C451 w_P000.n34 WIRE_CREF 2.3623204040527347e-16
C452 w_P000.n35 WIRE_CREF 1.9852845703125001e-14
C453 w_P000.n36 WIRE_CREF 7.3017175292968758e-16
C454 w_P000.n37 WIRE_CREF 1.3799810546875e-14
C455 w_P000.n38 WIRE_CREF 1.9328076171875002e-16
C456 w_P000.n39 WIRE_CREF 1.6800222656250001e-14
C457 w_P000.n40 WIRE_CREF 9.6640374755859383e-16
C458 w_P000.n41 WIRE_CREF 2.0483792968750001e-14
C459 w_P000.n42 WIRE_CREF 1.9328076171875002e-16
C460 w_P000.n43 WIRE_CREF 2.0004501953125002e-14
C461 w_P000.n44 WIRE_CREF 7.7312304687500007e-16
C462 w_P000.n45 WIRE_CREF 1.4143420898437501e-14
C463 w_P000.n46 WIRE_CREF 1.9328076171875002e-16
C464 w_P000.n47 WIRE_CREF 1.5253975585937502e-14
C465 w_P000.n48 WIRE_CREF 7.7312304687500007e-16
C466 w_P000.n49 WIRE_CREF 1.8937546875e-14
C467 w_P000.n50 WIRE_CREF 1.9328076171875002e-16
C468 w_P000.n51 WIRE_CREF 2.1550748046875003e-14
C469 w_P000.n52 WIRE_CREF 9.6640374755859383e-16
C470 w_P000.n53 WIRE_CREF 1.5689666992187501e-14
C471 w_P000.n54 WIRE_CREF 1.9328076171875002e-16
C472 w_P000.n55 WIRE_CREF 1.3707729492187501e-14
C473 w_P000.n56 WIRE_CREF 5.7984228515625003e-16
C474 w_P000.n57 WIRE_CREF 1.7391300781250002e-14
C475 w_P000.n58 WIRE_CREF 1.9328076171875002e-16
C476 w_P000.n59 WIRE_CREF 2.0004501953125002e-14
C477 w_P000.n60 WIRE_CREF 7.7312304687500007e-16
C478 w_P000.n61 WIRE_CREF 1.6593187499999999e-14
C479 w_P000.n62 WIRE_CREF 1.9328076171875002e-16
C480 w_P000.n63 WIRE_CREF 2.567596484375e-14
C481 w_P000.n64 WIRE_CREF 5.2499785156250007e-15
C482 w_P000.n65 WIRE_CREF 5.087757324218751e-15
C483 w_P000.n66 WIRE_CREF 6.9417094726562499e-15
C484 w_P000.n67 WIRE_CREF 6.3356025390625005e-15
C485 w_P000.n68 WIRE_CREF 4.2785849609374997e-15
C486 w_P000.n69 WIRE_CREF 3.6888022460937508e-15
C487 w_P000.n70 WIRE_CREF 6.9417094726562499e-15
C488 w_P000.n71 WIRE_CREF 6.3356025390625005e-15
C489 w_P000.n72 WIRE_CREF 4.2785849609374997e-15
C490 w_P000.n73 WIRE_CREF 3.6888027343750003e-15
C491 w_P000.n74 WIRE_CREF 6.9417094726562499e-15
C492 w_P000.n75 WIRE_CREF 6.3356025390625005e-15
C493 w_P000.n76 WIRE_CREF 4.2785849609374997e-15
C494 w_P000.n77 WIRE_CREF 3.6888027343750003e-15
C495 w_P000.n78 WIRE_CREF 6.7943803710937506e-15
C496 w_P000.n79 WIRE_CREF 6.9681547851562506e-15
C497 w_P000.n80 WIRE_CREF 6.4041982421875008e-15
C498 w_P000.n81 WIRE_CREF 5.8458017578124999e-15
C499 w_P000.n82 WIRE_CREF 5.2930048828125003e-15
C500 w_P000.n83 WIRE_CREF 4.1346079101562504e-15
C501 w_P000.n84 WIRE_CREF 4.2785849609374997e-15
C502 w_T0133.n0 WIRE_CREF 7.202830078125001e-15
C503 w_T0133.n1 WIRE_CREF 8.3283261718750002e-15
C504 w_T0133.n2 WIRE_CREF 7.7928144531250004e-15
C505 w_T0133.n3 WIRE_CREF 1.2835783203125002e-14
C506 w_T0157.n0 WIRE_CREF 6.1124301757812505e-15
C507 w_T0157.n1 WIRE_CREF 6.3590434570312508e-15
C508 w_T0157.n2 WIRE_CREF 6.6659956054687513e-15
C509 w_T0157.n3 WIRE_CREF 1.08131591796875e-14
C510 w_T0130.n0 WIRE_CREF 1.6434300781249999e-14
C511 w_T0130.n1 WIRE_CREF 1.07830244140625e-14
C512 w_T0130.n2 WIRE_CREF 1.0089713867187502e-14
C513 w_T0130.n3 WIRE_CREF 6.1382260742187503e-15
C514 w_T0130.n4 WIRE_CREF 5.4771875000000006e-15
C515 w_T0130.n5 WIRE_CREF 4.6819726562500007e-15
C516 w_T0130.n6 WIRE_CREF 6.3401669921875006e-15
C517 w_T0130.n7 WIRE_CREF 3.4441215991973879e-18
C518 w_T0130.n8 WIRE_CREF 1.7275889892578126e-15
C519 w_T0130.n9 WIRE_CREF 5.1441164016723638e-18
C520 w_T0130.n10 WIRE_CREF 7.6898889541625979e-18
C521 w_T0130.n11 WIRE_CREF 7.9302505493164068e-17
C522 w_T0130.n12 WIRE_CREF 3.387053728103638e-18
C523 w_T0130.n13 WIRE_CREF 7.6763401031494138e-18
C524 w_T0130.n14 WIRE_CREF 3.387053728103638e-18
C525 w_T0130.n15 WIRE_CREF 5.1441092491149905e-18
C526 w_T0130.n16 WIRE_CREF 7.9645332336425784e-17
C527 w_T0130.n17 WIRE_CREF 3.4441215991973879e-18
C528 w_T0130.n18 WIRE_CREF 1.6837348632812503e-15
C529 w_P005.n0 WIRE_CREF 1.3898850585937502e-14
C530 w_P005.n1 WIRE_CREF 3.9813144531250007e-15
C531 w_P005.n2 WIRE_CREF 6.4092324218750007e-15
C532 w_T0189.n0 WIRE_CREF 4.4774003906250008e-15
C533 w_T0179.n0 WIRE_CREF 5.54779736328125e-15
C534 w_T0195.n0 WIRE_CREF 5.5818959960937503e-15
C535 w_T0187.n0 WIRE_CREF 5.4709340820312506e-15
C536 w_T0177.n0 WIRE_CREF 4.4978232383728033e-18
C537 w_T0177.n1 WIRE_CREF 5.0808854103088376e-18
C538 w_T0177.n2 WIRE_CREF 2.1546449661254886e-17
C539 w_T0177.n3 WIRE_CREF 5.0808854103088376e-18
C540 w_T0177.n4 WIRE_CREF 5.7816967964172369e-18
C541 w_T0177.n5 WIRE_CREF 8.3008003234863284e-18
C542 w_T0177.n6 WIRE_CREF 1.9986080169677734e-17
C543 w_T0177.n7 WIRE_CREF 2.6501043701171873e-16
C544 w_T0177.n8 WIRE_CREF 3.1351583480834957e-17
C545 w_T0177.n9 WIRE_CREF 5.6833947753906259e-16
C546 w_T0177.n10 WIRE_CREF 3.5040588378906257e-17
C547 w_T0177.n11 WIRE_CREF 3.5040588378906257e-17
C548 w_T0177.n12 WIRE_CREF 4.5267999172210697e-20
C549 w_T0177.n13 WIRE_CREF 1.0600230712890627e-15
C550 w_T0177.n14 WIRE_CREF 3.3983552246093753e-15
C551 w_T0177.n15 WIRE_CREF 3.3808063964843752e-15
C552 w_T0177.n16 WIRE_CREF 1.1607194900512696e-17
C553 w_T0177.n17 WIRE_CREF 3.5040588378906257e-17
C554 w_T0177.n18 WIRE_CREF 3.5040588378906257e-17
C555 w_T0177.n19 WIRE_CREF 7.3151757812500004e-16
C556 w_T0177.n21 WIRE_CREF 2.0018543701171876e-15
C557 w_T0177.n22 WIRE_CREF 2.5317523956298833e-17
C558 w_T0177.n23 WIRE_CREF 7.3151757812500004e-16
C559 w_T0177.n24 WIRE_CREF 3.7803747558593752e-16
C560 w_T0177.n25 WIRE_CREF 3.5040588378906257e-17
C561 w_T0177.n26 WIRE_CREF 3.5040588378906257e-17
C562 w_T0177.n27 WIRE_CREF 1.0600230712890627e-15
C563 w_T0177.n28 WIRE_CREF 4.5267999172210697e-20
C564 w_T0177.n29 WIRE_CREF 3.6879447937011724e-17
C565 w_T0177.n30 WIRE_CREF 7.4516705322265622e-16
C566 w_T0177.n31 WIRE_CREF 8.2824716567993165e-18
C567 w_T0177.n32 WIRE_CREF 2.0012767791748048e-17
C568 w_T0177.n33 WIRE_CREF 5.0808854103088376e-18
C569 w_T0177.n34 WIRE_CREF 3.1354410171508796e-17
C570 w_T0177.n35 WIRE_CREF 5.0808854103088376e-18
C571 w_T0177.n36 WIRE_CREF 7.0081176757812504e-18
C572 w_T0177.n37 WIRE_CREF 4.5118722915649416e-18
C573 w_T0177.n38 WIRE_CREF 1.5160155296325685e-17
C574 w_T0177.n39 WIRE_CREF 4.0077672004699712e-18
C575 w_T0177.n40 WIRE_CREF 3.6879447937011724e-17
C576 w_T0177.n41 WIRE_CREF 7.0081176757812504e-18
C577 w_T0182.n0 WIRE_CREF 4.2772397994995127e-18
C578 w_T0182.n1 WIRE_CREF 4.8166623115539554e-18
C579 w_T0182.n2 WIRE_CREF 1.4371776580810547e-17
C580 w_T0182.n3 WIRE_CREF 4.8166623115539554e-18
C581 w_T0182.n4 WIRE_CREF 3.7993500232696539e-18
C582 w_T0182.n5 WIRE_CREF 7.8517236709594745e-18
C583 w_T0182.n6 WIRE_CREF 1.8971590042114258e-17
C584 w_T0182.n7 WIRE_CREF 7.567227172851563e-16
C585 w_T0182.n8 WIRE_CREF 2.9726953506469731e-17
C586 w_T0182.n9 WIRE_CREF 3.3207780761718752e-15
C587 w_T0182.n10 WIRE_CREF 1.1003582000732424e-17
C588 w_T0182.n11 WIRE_CREF 3.3218360900878913e-17
C589 w_T0182.n12 WIRE_CREF 3.3218360900878913e-17
C590 w_T0182.n13 WIRE_CREF 6.9347619628906259e-16
C591 w_T0182.n15 WIRE_CREF 1.7865903320312502e-15
C592 w_T0182.n16 WIRE_CREF 2.4000928878784181e-17
C593 w_T0182.n17 WIRE_CREF 5.8298950195312506e-16
C594 w_T0182.n18 WIRE_CREF 7.8691010475158705e-18
C595 w_T0182.n19 WIRE_CREF 1.8947175979614259e-17
C596 w_T0182.n20 WIRE_CREF 4.8166623115539554e-18
C597 w_T0182.n21 WIRE_CREF 2.9718139648437501e-17
C598 w_T0182.n22 WIRE_CREF 4.8166623115539554e-18
C599 w_T0182.n23 WIRE_CREF 6.643671989440919e-18
C600 w_T0182.n24 WIRE_CREF 4.2639212608337405e-18
C601 w_T0182.n25 WIRE_CREF 2.0425964355468752e-17
C602 w_T0182.n26 WIRE_CREF 5.4810295104980475e-18
C603 w_T0182.n27 WIRE_CREF 6.9347619628906259e-16
C604 w_T0182.n28 WIRE_CREF 5.1522656250000002e-16
C605 w_T0182.n29 WIRE_CREF 3.3218360900878913e-17
C606 w_T0182.n30 WIRE_CREF 3.3218360900878913e-17
C607 w_T0182.n31 WIRE_CREF 2.5203825683593749e-15
C608 w_T0182.n32 WIRE_CREF 4.2913913726806643e-20
C609 w_T0182.n33 WIRE_CREF 3.4961593627929687e-17
C610 w_T0182.n34 WIRE_CREF 6.643671989440919e-18
C611 w_T0181.n0 WIRE_CREF 3.8959243297576912e-18
C612 w_T0181.n1 WIRE_CREF 4.4009609222412114e-18
C613 w_T0181.n2 WIRE_CREF 1.8663103103637696e-17
C614 w_T0181.n3 WIRE_CREF 4.4009609222412114e-18
C615 w_T0181.n4 WIRE_CREF 5.0079903602600097e-18
C616 w_T0181.n5 WIRE_CREF 7.189987182617187e-18
C617 w_T0181.n6 WIRE_CREF 1.7311542510986331e-17
C618 w_T0181.n7 WIRE_CREF 2.7635433959960941e-16
C619 w_T0181.n8 WIRE_CREF 2.7156114578247073e-17
C620 w_T0181.n9 WIRE_CREF 7.489912109375e-16
C621 w_T0181.n10 WIRE_CREF 3.0351455688476567e-17
C622 w_T0181.n11 WIRE_CREF 3.0351455688476567e-17
C623 w_T0181.n12 WIRE_CREF 3.9210233837366106e-20
C624 w_T0181.n13 WIRE_CREF 9.181707763671876e-16
C625 w_T0181.n14 WIRE_CREF 9.2002626953124998e-15
C626 w_T0181.n15 WIRE_CREF 3.2134345703125e-15
C627 w_T0181.n16 WIRE_CREF 7.1741113662719735e-18
C628 w_T0181.n17 WIRE_CREF 1.7334657669067383e-17
C629 w_T0181.n18 WIRE_CREF 4.4009609222412114e-18
C630 w_T0181.n19 WIRE_CREF 2.7158563613891603e-17
C631 w_T0181.n20 WIRE_CREF 4.4009609222412114e-18
C632 w_T0181.n21 WIRE_CREF 6.0702910423278816e-18
C633 w_T0181.n22 WIRE_CREF 3.9080934524536139e-18
C634 w_T0181.n23 WIRE_CREF 1.3131422996520997e-17
C635 w_T0181.n24 WIRE_CREF 3.4714477062225347e-18
C636 w_T0181.n25 WIRE_CREF 2.589802001953125e-15
C637 w_T0181.n26 WIRE_CREF 6.112744750976562e-16
C638 w_T0181.n27 WIRE_CREF 3.0351455688476567e-17
C639 w_T0181.n28 WIRE_CREF 3.0351455688476567e-17
C640 w_T0181.n29 WIRE_CREF 9.181707763671876e-16
C641 w_T0181.n30 WIRE_CREF 3.9210233837366106e-20
C642 w_T0181.n31 WIRE_CREF 3.1944240570068363e-17
C643 w_T0181.n32 WIRE_CREF 3.1944240570068363e-17
C644 w_T0181.n33 WIRE_CREF 6.0702910423278816e-18
C645 w_T0194.n0 WIRE_CREF 4.4582052230834966e-18
C646 w_T0194.n1 WIRE_CREF 5.0204496383667e-18
C647 w_T0194.n2 WIRE_CREF 1.4979830741882326e-17
C648 w_T0194.n3 WIRE_CREF 5.0204496383667e-18
C649 w_T0194.n4 WIRE_CREF 3.9600961208343514e-18
C650 w_T0194.n5 WIRE_CREF 8.1839218139648449e-18
C651 w_T0194.n6 WIRE_CREF 1.977425575256348e-17
C652 w_T0194.n7 WIRE_CREF 7.496405029296876e-16
C653 w_T0194.n8 WIRE_CREF 3.0984666824340824e-17
C654 w_T0194.n9 WIRE_CREF 3.1974165039062503e-15
C655 w_T0194.n10 WIRE_CREF 1.1469131469726562e-17
C656 w_T0194.n11 WIRE_CREF 3.4623790740966797e-17
C657 w_T0194.n12 WIRE_CREF 3.4623790740966797e-17
C658 w_T0194.n13 WIRE_CREF 7.2281640625000003e-16
C659 w_T0194.n15 WIRE_CREF 1.9525650634765627e-15
C660 w_T0194.n16 WIRE_CREF 2.5016380310058598e-17
C661 w_T0194.n17 WIRE_CREF 1.0474144287109376e-15
C662 w_T0194.n18 WIRE_CREF 4.912882690429688e-16
C663 w_T0194.n19 WIRE_CREF 3.4623790740966797e-17
C664 w_T0194.n20 WIRE_CREF 3.4623790740966797e-17
C665 w_T0194.n21 WIRE_CREF 3.2638400878906252e-15
C666 w_T0194.n22 WIRE_CREF 4.4729549437761309e-20
C667 w_T0194.n23 WIRE_CREF 3.644078063964844e-17
C668 w_T0194.n24 WIRE_CREF 2.023099060058594e-16
C669 w_T0194.n25 WIRE_CREF 8.2020339965820324e-18
C670 w_T0194.n26 WIRE_CREF 1.9748809814453129e-17
C671 w_T0194.n27 WIRE_CREF 5.0204496383667e-18
C672 w_T0194.n28 WIRE_CREF 3.0975481033325196e-17
C673 w_T0194.n29 WIRE_CREF 5.0204496383667e-18
C674 w_T0194.n30 WIRE_CREF 6.9247584342956548e-18
C675 w_T0194.n31 WIRE_CREF 4.4443230628967288e-18
C676 w_T0194.n32 WIRE_CREF 2.1290163040161133e-17
C677 w_T0194.n33 WIRE_CREF 5.7129259109497074e-18
C678 w_T0194.n34 WIRE_CREF 7.2281640625000003e-16
C679 w_T0194.n35 WIRE_CREF 3.5243325805664061e-16
C680 w_T0194.n36 WIRE_CREF 3.4623790740966797e-17
C681 w_T0194.n37 WIRE_CREF 3.4623790740966797e-17
C682 w_T0194.n38 WIRE_CREF 1.0474144287109376e-15
C683 w_T0194.n39 WIRE_CREF 4.4729549437761309e-20
C684 w_T0194.n40 WIRE_CREF 3.644078063964844e-17
C685 w_T0194.n41 WIRE_CREF 6.9247584342956548e-18
C686 w_T0193.n0 WIRE_CREF 4.2401957511901855e-18
C687 w_T0193.n1 WIRE_CREF 4.7898607254028329e-18
C688 w_T0193.n2 WIRE_CREF 2.0312307357788086e-17
C689 w_T0193.n3 WIRE_CREF 4.7898607254028329e-18
C690 w_T0193.n4 WIRE_CREF 5.4505314826965337e-18
C691 w_T0193.n5 WIRE_CREF 7.8253450393676758e-18
C692 w_T0193.n6 WIRE_CREF 1.8841312408447265e-17
C693 w_T0193.n7 WIRE_CREF 5.8069799804687508e-16
C694 w_T0193.n8 WIRE_CREF 2.9555820465087892e-17
C695 w_T0193.n9 WIRE_CREF 3.1594990234375004e-15
C696 w_T0193.n10 WIRE_CREF 1.0942355155944825e-17
C697 w_T0193.n11 WIRE_CREF 3.3033523559570319e-17
C698 w_T0193.n12 WIRE_CREF 3.3033523559570319e-17
C699 w_T0193.n13 WIRE_CREF 6.8961749267578129e-16
C700 w_T0193.n15 WIRE_CREF 1.7522305908203126e-15
C701 w_T0193.n16 WIRE_CREF 2.3867380142211915e-17
C702 w_T0193.n17 WIRE_CREF 6.8961749267578129e-16
C703 w_T0193.n18 WIRE_CREF 4.9220944213867189e-16
C704 w_T0193.n19 WIRE_CREF 3.3033523559570319e-17
C705 w_T0193.n20 WIRE_CREF 3.3033523559570319e-17
C706 w_T0193.n21 WIRE_CREF 2.3815302734375003e-15
C707 w_T0193.n22 WIRE_CREF 4.2675126343965532e-20
C708 w_T0193.n23 WIRE_CREF 3.4767059326171878e-17
C709 w_T0193.n24 WIRE_CREF 7.7143762207031259e-16
C710 w_T0193.n25 WIRE_CREF 7.8080663681030277e-18
C711 w_T0193.n26 WIRE_CREF 1.8866470336914064e-17
C712 w_T0193.n27 WIRE_CREF 4.7898607254028329e-18
C713 w_T0193.n28 WIRE_CREF 2.9558485031127929e-17
C714 w_T0193.n29 WIRE_CREF 4.7898607254028329e-18
C715 w_T0193.n30 WIRE_CREF 6.6067047119140629e-18
C716 w_T0193.n31 WIRE_CREF 4.2534399032592783e-18
C717 w_T0193.n32 WIRE_CREF 1.4291808128356934e-17
C718 w_T0193.n33 WIRE_CREF 3.7782092094421388e-18
C719 w_T0193.n34 WIRE_CREF 6.6067047119140629e-18
C720 w_T0185.n0 WIRE_CREF 4.0378956794738776e-18
C721 w_T0185.n1 WIRE_CREF 4.5613365173339855e-18
C722 w_T0185.n2 WIRE_CREF 1.9343206405639649e-17
C723 w_T0185.n3 WIRE_CREF 4.5613365173339855e-18
C724 w_T0185.n4 WIRE_CREF 5.1904864311218264e-18
C725 w_T0185.n5 WIRE_CREF 7.4519977569580082e-18
C726 w_T0185.n6 WIRE_CREF 1.7942392349243164e-17
C727 w_T0185.n7 WIRE_CREF 2.4203710937500001e-16
C728 w_T0185.n8 WIRE_CREF 2.8145711898803712e-17
C729 w_T0185.n9 WIRE_CREF 7.0270745849609378e-16
C730 w_T0185.n10 WIRE_CREF 3.1457494735717778e-17
C731 w_T0185.n11 WIRE_CREF 3.1457494735717778e-17
C732 w_T0185.n12 WIRE_CREF 4.0639095008373267e-20
C733 w_T0185.n13 WIRE_CREF 9.5162988281250021e-16
C734 w_T0185.n14 WIRE_CREF 9.1249755859375007e-15
C735 w_T0185.n15 WIRE_CREF 3.6231237792968754e-15
C736 w_T0185.n16 WIRE_CREF 7.4355435371398932e-18
C737 w_T0185.n17 WIRE_CREF 1.7966350555419923e-17
C738 w_T0185.n18 WIRE_CREF 4.5613365173339855e-18
C739 w_T0185.n19 WIRE_CREF 2.8148248672485356e-17
C740 w_T0185.n20 WIRE_CREF 4.5613365173339855e-18
C741 w_T0185.n21 WIRE_CREF 6.2914986610412599e-18
C742 w_T0185.n22 WIRE_CREF 4.0505084991455079e-18
C743 w_T0185.n23 WIRE_CREF 1.3609945297241211e-17
C744 w_T0185.n24 WIRE_CREF 3.5979509353637701e-18
C745 w_T0185.n25 WIRE_CREF 2.6627221679687502e-15
C746 w_T0185.n26 WIRE_CREF 6.1420819091796875e-16
C747 w_T0185.n27 WIRE_CREF 3.1457494735717778e-17
C748 w_T0185.n28 WIRE_CREF 3.1457494735717778e-17
C749 w_T0185.n29 WIRE_CREF 9.5162988281250021e-16
C750 w_T0185.n30 WIRE_CREF 4.0639095008373267e-20
C751 w_T0185.n31 WIRE_CREF 3.3108322143554689e-17
C752 w_T0185.n32 WIRE_CREF 3.3108322143554689e-17
C753 w_T0185.n33 WIRE_CREF 6.2914986610412599e-18
C754 w_P004.n0 WIRE_CREF 7.0786904296875004e-15
C755 w_P004.n1 WIRE_CREF 6.9981494140625e-15
C756 w_P004.n2 WIRE_CREF 6.9981494140625e-15
C757 w_P004.n3 WIRE_CREF 6.9981494140625e-15
C758 w_P004.n4 WIRE_CREF 6.9981494140625e-15
C759 w_P004.n5 WIRE_CREF 6.9981494140625e-15
C760 w_P004.n6 WIRE_CREF 6.9981494140625e-15
C761 w_P004.n7 WIRE_CREF 6.9981494140625e-15
C762 w_P004.n8 WIRE_CREF 6.9981494140625e-15
C763 w_P004.n9 WIRE_CREF 6.9981494140625e-15
C764 w_P004.n10 WIRE_CREF 1.3912375000000002e-14
.ends nssoc_vco_local_hybrid_open_v2
