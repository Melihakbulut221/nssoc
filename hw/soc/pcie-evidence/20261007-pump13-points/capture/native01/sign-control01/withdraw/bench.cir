Independent current-source sign control
VCTRL vctrl 0 0.6
ITEST vctrl 0 1u
.control
set filetype=binary
save v(vctrl) i(vctrl)
op
write sign.raw all
quit
.endc
.end
