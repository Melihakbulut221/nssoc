* unchanged native diode model, no transistors or OSDI
.temp 125
.options method=gear maxord=2 itl4=100
*#######################################################################
*
* Copyright 2023 IHP PDK Authors
*
* Licensed under the Apache License, Version 2.0 (the "License");
* you may not use this file except in compliance with the License.
* You may obtain a copy of the License at
*
*    https://www.apache.org/licenses/LICENSE-2.0
*
* Unless required by applicable law or agreed to in writing, software
* distributed under the License is distributed on an "AS IS" BASIS,
* WITHOUT WARRANTIES OR CONDITIONS OF ANY KIND, either express or implied.
* See the License for the specific language governing permissions and
* limitations under the License.
*
*#######################################################################

.MODEL darea D (tnom=27 is=2.315E-019 n=1.009 ik=1.434E-007 rs=2.193E+005 cj0=9.371E-016 m=0.3036 vj=0.696 fc=0.5 bv=11.64 ibv=3.458E-007 tcv=0.001 nbv = 48.9 isr=7.413E-019 xti=5.039 trs=0 trs2=0 tt=7.009E-007)
.MODEL dperim D (tnom=27 is=3.851E-021 n=1.022 rs=1.688E+006 ik=7.838E-008 isr=1.011E-017 xti=3 bv=31.86 ibv=6.115E-014 nbv=112.1 cj=1.821E-017 m=0.01923 vj=0.598 tt=7.009E-007)
.MODEL dcorner D (tnom=27 is=6.502E-021 n=1 rs=4.857E+005 ik=1E-006 isr=0 xti=3 bv=11.64 ibv=3.458E-007 cj=0 m =0.5 vj=0.7)
.MODEL dparea D (tnom=27 is=8.569E-020 n=1.003 ik=2.957E-007 rs=1.728E+005 cj=8.252E-016 m=0.3171 vj=0.6628 fc=0.5 bv=12.14 ibv=1E-006 tcv=0.001 nbv=11.85 isr=2.421E-019 xti=4.56 trs=0 trs2=0 tt=1E-012)
.MODEL dpperim D (tnom=27 is=1.186E-020 n=1.006 rs=1.577E+006 ik=2.158E-008 isr=7.211E-018 xti = 4.118 bv=27.26 ibv=1.832E-011 nbv=32.47 cj=3.657E-017 m=0.1512 vj=0.5241 tt=1E-012)
.MODEL dpcorner D (tnom=27 is=6.965E-021 n=1 rs=4.734E+005 ik=1.19E-008 isr=0 xti=3 cj=0 m=0.5 vj=0.7)

**************************************
* Device: dantenna
* Testfield: T262
* Technology: IHP SG13S technologies
* Lot: AWL403#A
* Wafer: 19
* Chip: 4,7
* Segment: S350B
* DUTs: D1 (area), D2 (perimeter) and D4 (corners)
* Temperature range: -40°C ... +125°C
* DC range: -15V ... 1V
* Date: 05.03.2013
* 24.03.2015 WW area dependency and temperature dependency
* for dantenna and dpantenna break down updated
* Remarks: model is designed for reverse direction of the diodes
*          NO statistics
*          initial model
*  DEV_A = area of the diode in um*umnew
*  DEV_P = perimeter of the diode in um
*  DEV_C = number of corners (default=4)
*************************************

.subckt dantenna 1 2
*subckt dantenna (bn C)
*                (anode  cathode)
*      (substrate/pWell  NSD)
.params l=780n   w=780n   DEV_A=(l*w)/1p  DEV_P=(l+w)/0.5u  DEV_C=4
D1 1 2 darea area=DEV_A
D2 1 2 dperim area=DEV_P
D3 1 2 dcorner area=DEV_C
.ends dantenna

**************************************
* Device: dpantenna
* Testfield: T262
* Technology: IHP SG13S technologies
* Lot: AWL403#A
* Wafer: 19
* Chip: 4,7
* Segment: S351B
* DUTs: D1 (area), D2 (perimeter) and D4 (corners)
* Temperature range: -40°C ... +125°C
* DC range: -15V ... 1V
* Date: 05.03.2013
* Remarks: model is designed for reverse direction of the diodes
*          bipolar effect in forward direction is NOT modeled
*          NO statistics
*          initial model
*  DEV_A = area of the diode in um*um
*  DEV_P = perimeter of the diode in um
*  DEV_C = number of corners (default=4)
*************************************

.subckt dpantenna 1 2
*              (PSD  nWell)
*             (anode  cathode)
.params l=780n  w=780n  DEV_A=(l*w)/1p  DEV_P=(l+w)/0.5u  DEV_C=4
D1 1 2 dparea area=DEV_A
D2 1 2 dpperim area=DEV_P
D3 1 2 dpcorner area=DEV_C
.ends dpantenna

**************************************
* Device: isolbox
* Testfield: T327
* Technology: all IHP 0u13 technologies (SG13S, SG13G2)
* Lot: PQE701
* Wafer: 08
* Chip: 6,4;6,5
* DUTs: IS102..107;IS202...IS210
* Temperature range: -40°C ... +125°C
* DC range: -80V ... 1V (depending on pWellBlock width)
* Operator: Teply
* Date: 2016-03-31
* Remarks: bipolar effect NOT taken into account
*          model is designed for reverse direction of the diodes
*          NO statistics
*          initial model
*************************************

*******************************************************************************
* isolbox
*******************************************************************************

.subckt isolbox isosub NWell bn
.params
+l=3u
+w=3u
+aw=(w-2.1u)*(l-2.1u)
+pw=(w+l)*2-8*1.05u
+ab=(w*l)
+pb=(w+l)*2
+xd=0
+mf=1
+scaling=1e-6
+xds=xd/scaling
+pbs=pb/scaling
+abus=ab/(scaling*scaling)
+pws=pw/scaling
+aws=aw/(scaling*scaling)

xdpwdnw isosub NWell dpwdnw l='l' w='w'
+aw=aw
+pw=pw
+xd=xd
+mf=mf
+scaling=scaling
+xds=xds
+pws=pws
+aws=aws

xdnwpsub NWell bn ddnwpsub l='l' w='w'
+ab=ab
+pb=pb
+xd=xd
+mf=mf
+scaling=scaling
+xds=xds
+pbs=pbs
+abus=abus

.ends isolbox

.subckt dpwdnw isosub NWell
.params
+l=3u
+w=3u
+aw=(w-2.1u)*(l-2.1u)
+pw=(w+l)*2-8*1.05u
+xd=0
+mf=1
+scaling=1e-6
+xds=xd/scaling
+pws=pw/scaling
+aws=aw/(scaling*scaling)

dinner isosub NWell dinner_mod area=mf*aws pj=0
dinneredge isosub NWell dinneredge_mod area=mf*pws pj=mf*pws
dinrevl NWell isosub dinrevl_mod area=mf*aws pj=0
dinrevlside NWell isosub dinrevlside_mod area=mf*pws pj=0
dinrevh NWell isosub dinrevh_mod area=mf*aws pj=0
dincaparea isosub NWell dincaparea_mod area=mf*aws pj=mf*pws-3

.model dinner_mod d tnom=27 level=1 tlevc=0 tlev=2
+is=1.5e-19
+n=1.02
+ik=100e-9
+xti=1.9
+bv=9.7
+ibv=1e-12
+nbv=0.1
+tcv=-698.557e-6
+rs=5e5

.model dinrevl_mod d tnom=27 level=1 tlevc=0 tlev=2
+is=1e-18
+n=100
+xti=2200

.model dinrevlside_mod d tnom=27 level=1 tlevc=0 tlev=2
+is=10e-18
+n=100
+xti=2200

.model dinrevh_mod d tnom=27 level=1 tlevc=0 tlev=2
+is=3e-21
+n=30
+xti=700

.model dincaparea_mod d tnom=27 level=1 tlevc=0 tlev=2
+is=1e-25
+cj=967.2e-18
+cjsw=436e-18
+mj=0.3436
+mjsw=0.3234
+vj=0.7312
+php=0.7036

.model dinneredge_mod d tnom=27 level=1 tlevc=0 tlev=2
+is=3.89e-20
+jsw=7.239e-20
+n=1.01
+ik=3e-6
*+ikp=10e-6
+xti=1.529
+bv=9.7
+ibv=1e-12
+nbv=0.1
+tcv=-698.557e-6
+isr=20e-18
+rs=5e4
*+rsw=12e3

.ends dpwdnw

.subckt ddnwpsub NWell bn
.params
+l=3u
+w=3u
+ab=(w*l)
+pb=(w+l)*2
+xd=0
+mf=1
+scaling=1e-6
+xds=xd/scaling
+pbs=pb/scaling
+abus=ab/(scaling*scaling)

douter bn NWell dsub_mod area=mf*abus pj=0

.if (xds<0.6)
   douteredge0 bn NWell dsubedge0_mod area=mf*pbs pj=mf*pbs
.else
   douteredgexds bn NWell dsubedgexds_mod area=mf*pbs pj=mf*pbs
.endif

doutcapcorner bn NWell doutcapcorner_mod area=1.0e-10 pj=mf*14.4
doutcaparea bn NWell doutcaparea_mod area=mf*abus pj=mf*pbs

.model dsub_mod d tnom=27 level=1 tlevc=0 tlev=2
+is=4.052e-18
+n=1.01
+ik=1.023e-9
+xti=2.112
+bv=94.7
+nbv=6
+tcv=-422.386e-6
+isr=86e-18
+rs=5e5

.model dsubedge0_mod d tnom=27 level=1 tlevc=0 tlev=2
+is=4.052e-18
+n=1.01
+jsw=17.26e-18
+ik=1.023e-9
*+ikp=10.73e-9
+xti=2.112
+bv=13.54
+tcv=-747.415e-6
+isr=10e-18
+nbv=0.5
+rs=10e3

.model dsubedgexds_mod d tnom=27 level=1 tlevc=0 tlev=2
+is=4.052e-18
+n=1.01
+jsw=17.26e-18
+ik=1.023e-9
*+ikp=10.73e-9
+xti=2.112
+bv='(-11.70818-8.218455*xds+9.586918*ln(xds)+51.45397*sqrt(xds))'
+tcv=-980.73e-6
+nbv='5.452942+(0.4699715-5.452942)/((1+((xds/0.982607)**308.6349))**0.005495705)'
+isr=1e-16
+rs=28e3
*+rsw=16e3

.model doutcapcorner_mod d tnom=27 level=1 tlevc=0 tlev=2
+jsw=1e-25
+cjsw='(389.8354-784.332*xds+736.9852*(xds**1.33)-91.4155*xds*xds+5.388092*xds*xds*xds)*1e-18'
+mjsw='0.3029153+16.37804*xds-16.45657*(xds**0.9972906)'
+php='0.05502945+((0.51-0.05502945)/(1+((xds/1.059131)**7.087824)))'
+bv='(213.2898+(145-213.2898)/((1+(xds/0.9145351)**38.88081)**0.02169905))'
+nbv=200

.model doutcaparea_mod d tnom=27 level=1 tlevc=0 tlev=2
+is=1e-25
+cj=70.13e-18
+mj=0.3874
+vj=0.3357
+cjsw='(471.3008-320.939*xds+91.4155*xds*xds-5.388092*xds*xds*xds)*1e-18'
+mjsw='0.2842892-0.1665323*xds+0.06902971*xds*xds-0.004775717*xds*xds*xds'
+php='0.6372219-0.6615502*sqrt(xds)+0.2246224*xds-0.0005250178*xds*xds*xds'
+bv='(262.7082+((154.5533-262.7082)/(1+(xds/3.044691)**1.691568)))'
+nbv=200

.ends ddnwpsub

Vdrive gate 0 PWL(0 3 20n 3 20.12n 0 50n 0)
D1 0 gate darea area=0.3072
.control
set wr_singlescale
set wr_vecnames
save v(gate) i(vdrive)
option method=gear maxord=2 itl4=100
tran 1p 50n 0 1p
echo NSSOC_DIODE_SOLVER_READBACK
option
wrdata wave.dat v(gate) i(vdrive)
echo NSSOC_DIODE_CAPTURE_END
quit
.endc
.end
