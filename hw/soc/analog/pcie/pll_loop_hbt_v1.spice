* SPDX-FileCopyrightText: 2026 Hasan Melih Akbulut
* SPDX-License-Identifier: CERN-OHL-W-2.0
* Original connected schematic startup fixture: real HBT VCO and /80 feedback.
* Negative Kvco requires feedback at the PFD positive input and REF at negative.
* The pump drives VCTRL through a finite native biased RC filter; no ideal
* internal clock/divider/detector/control clamp and no lock/signoff assertion.
* Separate VCO2.3V, divider/PFD2.5V and logic1.2V nominal supplies.
.subckt nssoc_pll_loop_hbt_v1 ref reset clearb clkp clkn qp qn fb fbbar up down vctrl vco_avdd div_avdd core_vdd avss sub
XCHAIN vctrl clearb clkp clkn qp qn fb fbbar vco_avdd div_avdd core_vdd avss sub nssoc_pll_feedback_chain_v1
XDET fb ref reset up down vctrl div_avdd avss sub nssoc_pll_pfd_cp_hv_v1
* Finite DC bias near0.851V before pump correction; actual resistor/capacitor
* models determine voltage, pole and ripple. This is not a type-II ideal loop.
XRHI vco_avdd vctrl sub rppd w=1u l=80u b=0 sw_et=1
XRLO vctrl avss sub rppd w=1u l=47u b=0 sw_et=1
XC vctrl avss cap_cmim w=10u l=10u
.ends nssoc_pll_loop_hbt_v1
