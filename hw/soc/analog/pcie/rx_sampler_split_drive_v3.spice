* Fourfold-drive load-stress candidate:16HBT/3native LV NMOS/12rppd. No physical or PHY acceptance.
* MOS reference8um/0.3um, tails128um/0.3um; fixed16:1 width ratio. HBT Nx and load width scale4x.
* SPDX-FileCopyrightText: 2026 Hasan Melih Akbulut
* SPDX-License-Identifier: CERN-OHL-W-2.0
* Development CML master/slave sampler, not a CDR or complete PCIe PHY.
* External AVDD=2.5 V, AVSS=0 V, IREF=0.5 mA and differential clock required.
* RX v2 remains separately powered from 1.8 V. Native resistive level shift
* loads its actual outputs; no ideal voltage gain or behavioral latch exists.
* Clock target: 8 GHz, common mode 1.29 V, differential levels +/-0.30 V.
* Preamplifier/substrate/pad parasitics are not supplied by this schematic.

.subckt nssoc_cml_latch_split_drive_v3 dp dn qp qn cp cn avdd avss sub ref
XDP qn dp se sub npn13G2 Nx=8
XDN qp dn se sub npn13G2 Nx=8
XLP qn qp he sub npn13G2 Nx=8
XLN qp qn he sub npn13G2 Nx=8
XCS0 se cp te sub npn13G2 Nx=8
XCS1 se cp te sub npn13G2 Nx=8
XCH0 he cn te sub npn13G2 Nx=8
XCH1 he cn te sub npn13G2 Nx=8
XT te ref avss sub sg13_lv_nmos w=128u l=.3u ng=1
XRP avdd qp sub rppd w=32u l=2.12u b=0 sw_et=1
XRN avdd qn sub rppd w=32u l=2.12u b=0 sw_et=1
* Weak native bleeders keep the inactive emitter nodes from floating.
XBS se avss sub rppd w=1u l=38.4u b=0 sw_et=1
XBH he avss sub rppd w=1u l=38.4u b=0 sw_et=1
.ends nssoc_cml_latch_split_drive_v3

.subckt nssoc_rx_sampler_split_drive_v3 dp dn qp qn clkp clkn avdd avss sub iref
XREF iref iref avss sub sg13_lv_nmos w=8u l=.3u ng=1
XIP dp lp sub rppd w=1u l=3.6u b=0 sw_et=1
XIN dn ln sub rppd w=1u l=3.6u b=0 sw_et=1
XBP avdd lp sub rppd w=1u l=3.6u b=0 sw_et=1
XBN avdd ln sub rppd w=1u l=3.6u b=0 sw_et=1
* Master tracks low clock; slave tracks high clock, capturing a rising edge.
XM lp ln mp mn clkn clkp avdd avss sub iref nssoc_cml_latch_split_drive_v3
XS mp mn qp qn clkp clkn avdd avss sub iref nssoc_cml_latch_split_drive_v3
.ends nssoc_rx_sampler_split_drive_v3
