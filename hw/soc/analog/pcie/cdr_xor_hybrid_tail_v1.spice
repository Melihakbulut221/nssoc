* SPDX-FileCopyrightText: 2026 Hasan Melih Akbulut
* SPDX-License-Identifier: CERN-OHL-W-2.0
* Explicit unchanged XOR polarity and separate body/return port mapping.
.subckt nssoc_cdr_xor_hybrid_tail_v1 dp dn ep en qp qn avdd avss sub iref
XCORE sub dp dn dn dp iref ep en qp qn avss avdd nssoc_cdr_xor_core_hybrid_tail_v1
.ends nssoc_cdr_xor_hybrid_tail_v1
