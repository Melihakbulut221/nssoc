* SPDX-FileCopyrightText: 2026 Hasan Melih Akbulut
* SPDX-License-Identifier: CERN-OHL-W-2.0
* Separate v3: four second-stage collector loads L2.12->2.4um.
* The first core retains its upward common-mode network. The second network
* lowers the first core's high output common mode; no ideal level shift.
.subckt nssoc_clock_div4_hbt_v3 clkp clkn qp qn avdd avss sub
XFIRST clkp clkn s1p s1n avdd avss sub nssoc_clock_div2_conditioned_hbt
XSP s1p ckp sub rppd w=2u l=8u b=0 sw_et=1
XSN s1n ckn sub rppd w=2u l=8u b=0 sw_et=1
XDP ckp avss sub rppd w=1u l=6u b=0 sw_et=1
XDN ckn avss sub rppd w=1u l=6u b=0 sw_et=1
XCP s1p ckp cap_cmim w=20u l=20u
XCN s1n ckn cap_cmim w=20u l=20u
XSECOND ckp ckn qp qn avdd avss sub nssoc_clock_div2_stage2_v3
.ends nssoc_clock_div4_hbt_v3

* SPDX-FileCopyrightText: 2026 Hasan Melih Akbulut
* SPDX-License-Identifier: CERN-OHL-W-2.0
* Native HBT master/slave toggle prescaler, not a PLL/CDR or PCIe PHY.
* Include the exact frozen rx_sampler_hbt_v2.spice before this subcircuit.
* Master tracks low clock, slave high; slave QN/Q drives master DP/DN.
* Independent nominal2.5V rail and a native resistor/HBT bias reference.
* Small fixed native MIM mismatch supplies a physical startup asymmetry.
* No ideal clock, gain, logic state, IC, UIC or startup current kick exists.
.subckt nssoc_clock_div2_stage2_v3 clkp clkn qp qn avdd avss sub
XBIAS avdd ref sub rppd w=1u l=12.7u b=0 sw_et=1
XREF ref ref avss sub npn13G2 Nx=1
XM qn qp mp mn clkn clkp avdd avss sub ref nssoc_cml_latch_div4_v3
XS mp mn qp qn clkp clkn avdd avss sub ref nssoc_cml_latch_div4_v3
XSEEDP mp avss cap_cmim w=2.2u l=2u
XSEEDN mn avss cap_cmim w=2u l=2u
.ends nssoc_clock_div2_stage2_v3

.subckt nssoc_cml_latch_div4_v3 dp dn qp qn cp cn avdd avss sub ref
XDP qn dp se sub npn13G2 Nx=2
XDN qp dn se sub npn13G2 Nx=2
XLP qn qp he sub npn13G2 Nx=2
XLN qp qn he sub npn13G2 Nx=2
XCS se cp te sub npn13G2 Nx=4
XCH he cn te sub npn13G2 Nx=4
XT te ref avss sub npn13G2 Nx=4
XRP avdd qp sub rppd w=8u l=2.4u b=0 sw_et=1
XRN avdd qn sub rppd w=8u l=2.4u b=0 sw_et=1
* Weak native bleeders keep the inactive emitter nodes from floating.
XBS se avss sub rppd w=1u l=38.4u b=0 sw_et=1
XBH he avss sub rppd w=1u l=38.4u b=0 sw_et=1
.ends nssoc_cml_latch_div4_v3
