* SPDX-FileCopyrightText: 2026 Hasan Melih Akbulut
* SPDX-License-Identifier: CERN-OHL-W-2.0
* Native thirty devices plus distributed pump metal RC; unqualified extraction.
.subckt nssoc_pump30_wire_v1 sub vctrl div_avdd vco_avdd up avss down wire_cref
XD0001 T001_rppd_1 T001_rppd_2 n_1 rppd w=1.0u l=47.0u ps=0.0u b=0 m=1 sw_et=1
XD0002 T002_D T002_G T002_S n_1 sg13_hv_nmos l=0.45u w=2u as=0.68p ad=0.68p ps=4.68u pd=4.68u rfmode=0 ng=1 m=1
XD0003 T003_D T003_G T003_S n_13 sg13_hv_pmos l=0.45u w=4u as=1.36p ad=1.36p ps=8.68u pd=8.68u rfmode=0 ng=1 m=1
XD0004 T004_mim_top T004_mim_btm cap_cmim w=10.0u l=10.0u
XD0005 T005_D T005_G T005_S n_11 sg13_hv_pmos l=2u w=6.4u as=2.176p ad=2.176p ps=13.48u pd=13.48u rfmode=0 ng=1 m=1
XD0006 T006_D T006_G T006_S n_10 sg13_hv_pmos l=2u w=8u as=2.72p ad=2.72p ps=16.68u pd=16.68u rfmode=0 ng=1 m=1
XD0007 T007_D T007_G T007_S n_1 sg13_hv_nmos l=2u w=2u as=0.68p ad=0.68p ps=4.68u pd=4.68u rfmode=0 ng=1 m=1
XD0008 T008_D T008_G T008_S n_1 sg13_hv_nmos l=2u w=2u as=0.68p ad=0.68p ps=4.68u pd=4.68u rfmode=0 ng=1 m=1
XD0009 T009_D T009_G T009_S n_1 sg13_hv_nmos l=2u w=2u as=0.68p ad=0.68p ps=4.68u pd=4.68u rfmode=0 ng=1 m=1
XD0010 T010_rppd_1 T010_rppd_2 n_1 rppd w=1.0u l=80.0u ps=0.0u b=0 m=1 sw_et=1
XD0011 T011_rppd_1 T011_rppd_2 n_1 rppd w=1.0u l=80.0u ps=0.0u b=0 m=1 sw_et=1
XD0012 T012_D T012_G T012_S n_1 sg13_hv_nmos l=0.45u w=8u as=2.72p ad=2.72p ps=16.68u pd=16.68u rfmode=0 ng=1 m=1
XD0013 T013_TIE n_1 ptap1 R=81.66666666666666666666666668 w=2u l=2u
XD0014 T014_TIE n_1 ptap1 R=81.66666666666666666666666668 w=2u l=2u
XD0015 T015_TIE n_1 ptap1 R=81.66666666666666666666666668 w=2u l=2u
XD0016 T016_TIE n_1 ptap1 R=81.66666666666666666666666668 w=2u l=2u
XD0017 T017_TIE n_1 ptap1 R=81.66666666666666666666666668 w=2u l=2u
XD0018 T018_TIE n_1 ptap1 R=81.66666666666666666666666668 w=2u l=2u
XD0019 T019_TIE n_1 ptap1 R=81.66666666666666666666666668 w=2u l=2u
XD0020 T020_TIE n_1 ptap1 R=81.66666666666666666666666668 w=2u l=2u
XD0021 T021_TIE n_1 ptap1 R=81.66666666666666666666666668 w=2u l=2u
XD0022 T022_TIE n_1 ptap1 R=81.66666666666666666666666668 w=2u l=2u
XD0023 T023_TIE n_1 ptap1 R=81.66666666666666666666666668 w=2u l=2u
XD0024 T024_TIE n_1 ptap1 R=81.66666666666666666666666668 w=2u l=2u
XD0025 T025_TIE n_1 ptap1 R=81.66666666666666666666666668 w=2u l=2u
XD0026 T026_TIE n_12 ntap1 R=81.66666666666666666666666668 w=2u l=2u
XD0027 T027_TIE n_11 ntap1 R=81.66666666666666666666666668 w=2u l=2u
XD0028 T028_TIE n_13 ntap1 R=81.66666666666666666666666668 w=2u l=2u
XD0029 T029_TIE n_10 ntap1 R=81.66666666666666666666666668 w=2u l=2u
XD0030 T030_D T030_G T030_S n_12 sg13_hv_pmos l=0.45u w=8u as=2.72p ad=2.72p ps=16.68u pd=16.68u rfmode=0 ng=1 m=1
R0 sub P_sub.n0 4.54667
R1 P_sub.n1 P_sub.n0 2.93333
R2 P_sub.n2 P_sub.n1 2.93333
R3 P_sub.n3 P_sub.n2 2.93333
R4 P_sub.n4 P_sub.n3 2.93333
R5 P_sub.n5 P_sub.n4 2.93333
R6 P_sub.n6 P_sub.n5 2.93333
R7 P_sub.n7 P_sub.n6 2.93333
R8 P_sub.n8 P_sub.n7 2.93333
R9 P_sub.n9 P_sub.n8 2.93333
R10 P_sub.n10 P_sub.n9 2.93333
R11 P_sub.n11 P_sub.n10 2.93333
R12 T018_TIE P_sub.n11 46.2867
R13 T021_TIE P_sub.n11 43.3533
R14 T025_TIE P_sub.n10 43.3533
R15 T023_TIE P_sub.n9 42.4733
R16 T014_TIE P_sub.n8 43.3533
R17 T020_TIE P_sub.n7 42.4733
R18 T019_TIE P_sub.n6 42.4733
R19 T015_TIE P_sub.n5 43.3533
R20 T016_TIE P_sub.n4 43.3533
R21 T022_TIE P_sub.n3 43.3533
R22 T024_TIE P_sub.n2 42.4733
R23 T017_TIE P_sub.n1 42.4733
R24 T013_TIE P_sub.n0 43.3533
R25 T010_rppd_1 vco_avdd 74.3572
R26 up P_up.n0 27.4267
R27 T002_G P_up.n0 45.6358
R28 T003_G P_up.n0 42.5558
R29 T008_D T012_S 111.169
R30 T005_D T030_S 112.652
R31 div_avdd P_div_avdd.n0 3.37333
R32 P_div_avdd.n1 P_div_avdd.n0 8.8
R33 P_div_avdd.n2 P_div_avdd.n1 0.88
R34 P_div_avdd.n3 P_div_avdd.n2 2.05333
R35 P_div_avdd.n4 P_div_avdd.n3 0.88
R36 P_div_avdd.n5 P_div_avdd.n4 2.93333
R37 P_div_avdd.n6 P_div_avdd.n5 7.92
R38 T028_TIE P_div_avdd.n6 41.3733
R39 P_div_avdd.n6 T003_S 49.973
R40 T026_TIE P_div_avdd.n5 40.4933
R41 T027_TIE P_div_avdd.n4 40.4933
R42 P_div_avdd.n3 T005_S 50.798
R43 T029_TIE P_div_avdd.n2 40.4933
R44 P_div_avdd.n1 T006_S 51.348
R45 T011_rppd_1 P_div_avdd.n0 39.8905
R46 T012_G down 62.9425
R47 T030_G.n0 T030_G 9
R48 T030_G T030_G.n1 53.8492
R49 T002_D T030_G.n1 57.2282
R50 T003_D T030_G.n1 54.8357
R51 T007_D T007_D.n0 55.5672
R52 T007_D.n1 T007_D.n0 0.293333
R53 T005_G T007_D.n1 46.9027
R54 T006_G T007_D.n1 43.852
R55 T006_D T007_D.n0 54.2564
R56 avss P_avss.n0 6.30667
R57 P_avss.n1 P_avss.n0 2.93333
R58 P_avss.n2 P_avss.n1 14.6667
R59 P_avss.n3 P_avss.n2 5.86667
R60 P_avss.n4 P_avss.n3 6.16
R61 T004_mim_btm P_avss.n4 30.1733
R62 T001_rppd_2 P_avss.n4 36.8428
R63 P_avss.n3 T002_S 48.8455
R64 P_avss.n2 T008_S 48.8455
R65 P_avss.n1 T007_S 48.8455
R66 P_avss.n0 T009_S 48.8455
R67 vctrl P_vctrl.n0 18.3333
R68 P_vctrl.n1 P_vctrl.n0 2.93333
R69 P_vctrl.n2 P_vctrl.n1 11.7333
R70 P_vctrl.n3 P_vctrl.n2 2.64
R71 T004_mim_top P_vctrl.n3 33.8145
R72 T001_rppd_1 P_vctrl.n3 42.0905
R73 T010_rppd_2 P_vctrl.n2 37.0628
R74 T012_D P_vctrl.n1 53.7174
R75 T030_D P_vctrl.n0 53.7174
R76 T011_rppd_2.n0 T011_rppd_2 9
R77 T011_rppd_2 T011_rppd_2.n1 40.4361
R78 T011_rppd_2.n1 T011_rppd_2.n2 0.293333
R79 T011_rppd_2.n2 T011_rppd_2.n3 2.93333
R80 T008_G T011_rppd_2.n3 58.5187
R81 T007_G T011_rppd_2.n3 43.852
R82 T009_G T011_rppd_2.n2 43.852
R83 T009_D T011_rppd_2.n1 52.1939
C0 T030_G vctrl 4.3202499999999999e-15
C1 T011_rppd_2 down 1.1779499511718751e-15
C2 sub T012_S 6.329299926757813e-16
C3 vctrl down 3.5756899414062506e-15
C4 vco_avdd sub 2.9887899780273437e-16
C5 T011_rppd_2 sub 4.4297900390625001e-15
C6 sub vctrl 2.4885400390624999e-15
C7 avss T030_S 5.8608502197265628e-16
C8 avss T007_D 4.1685698242187499e-15
C9 div_avdd up 2.5835400390625001e-15
C10 T030_G up 7.4815600585937513e-15
C11 div_avdd T030_G 5.4280600585937498e-15
C12 T030_S T007_D 3.9090600585937502e-15
C13 avss T012_S 3.5931899414062506e-15
C14 div_avdd down 3.5606499023437507e-15
C15 T030_G down 2.9288900756835943e-16
C16 avss vco_avdd 2.9802600097656253e-16
C17 avss T011_rppd_2 4.9694501953125004e-15
C18 vco_avdd T030_S 5.8681799316406252e-16
C19 avss vctrl 1.0835599609375001e-14
C20 sub up 6.2580000000000003e-15
C21 vco_avdd T007_D 1.1736400146484377e-15
C22 T030_S T011_rppd_2 5.9395697021484375e-16
C23 div_avdd sub 1.1632099609375002e-14
C24 T030_G sub 9.7459997558593758e-16
C25 T011_rppd_2 T007_D 5.7082700195312509e-15
C26 T030_S vctrl 3.8454299316406254e-15
C27 vctrl T007_D 1.1736400146484377e-15
C28 vco_avdd T012_S 5.8681799316406252e-16
C29 sub down 5.9530097656250004e-15
C30 T011_rppd_2 T012_S 4.181830078125001e-15
C31 vctrl T012_S 3.8456101074218753e-15
C32 vco_avdd T011_rppd_2 1.4724000244140625e-15
C33 vco_avdd vctrl 6.9252998046874998e-15
C34 T011_rppd_2 vctrl 4.6265498046875009e-15
C35 avss up 7.3894201660156253e-16
C36 avss div_avdd 6.5354702148437507e-15
C37 avss T030_G 4.0263400878906252e-15
C38 T030_S up 5.8681799316406252e-16
C39 T030_S div_avdd 3.1441899414062506e-15
C40 T030_S T030_G 3.1933999633789062e-16
C41 T007_D up 1.1736400146484377e-15
C42 div_avdd T007_D 8.0943701171875016e-15
C43 avss down 2.9519699096679686e-16
C44 T012_S up 5.8681799316406252e-16
C45 T030_S down 5.8681799316406252e-16
C46 div_avdd T012_S 5.8912701416015631e-16
C47 T007_D down 1.1725999755859376e-15
C48 avss sub 3.7731799316406251e-15
C49 vco_avdd up 4.58710009765625e-15
C50 vco_avdd T030_G 8.9092797851562512e-16
C51 T011_rppd_2 up 1.4724000244140625e-15
C52 div_avdd T011_rppd_2 2.4431699218750003e-15
C53 T030_G T011_rppd_2 3.0054699707031256e-16
C54 T012_S down 4.3687600708007814e-16
C55 T030_S sub 5.9344799804687504e-16
C56 sub T007_D 1.3488900146484375e-15
C57 vctrl up 5.8146801757812506e-16
C58 div_avdd vctrl 5.8772900390625014e-16
C59 sub wire_cref 1.9513822021484376e-15
C60 T025_TIE wire_cref 3.744982421875e-15
C61 T024_TIE wire_cref 3.4640942382812502e-15
C62 T023_TIE wire_cref 3.4640942382812502e-15
C63 T022_TIE wire_cref 3.744982421875e-15
C64 T021_TIE wire_cref 3.744982421875e-15
C65 T020_TIE wire_cref 3.4640942382812502e-15
C66 T019_TIE wire_cref 3.4640942382812502e-15
C67 T018_TIE wire_cref 4.2349711914062503e-15
C68 T017_TIE wire_cref 3.4640942382812502e-15
C69 T016_TIE wire_cref 3.744982421875e-15
C70 T015_TIE wire_cref 3.744982421875e-15
C71 T014_TIE wire_cref 3.744982421875e-15
C72 T013_TIE wire_cref 3.744982421875e-15
C73 vco_avdd wire_cref 1.5760679687500002e-14
C74 T010_rppd_1 wire_cref 7.7516210937500003e-15
C75 up wire_cref 6.2275366210937509e-15
C76 T003_G wire_cref 1.7350418701171876e-15
C77 T002_G wire_cref 2.0104410400390626e-15
C78 T012_S wire_cref 9.9702695312500017e-15
C79 T008_D wire_cref 1.0248330078125002e-14
C80 T030_S wire_cref 1.0160134765625e-14
C81 T005_D wire_cref 1.0157564453125001e-14
C82 div_avdd wire_cref 1.067612548828125e-15
C83 T029_TIE wire_cref 2.2748850097656254e-15
C84 T028_TIE wire_cref 2.364514892578125e-15
C85 T027_TIE wire_cref 2.2748850097656254e-15
C86 T026_TIE wire_cref 2.2748850097656254e-15
C87 T011_rppd_1 wire_cref 2.1219531250000003e-15
C88 T006_S wire_cref 1.6804676513671876e-15
C89 T005_S wire_cref 1.6888900146484377e-15
C90 T003_S wire_cref 1.7021649169921877e-15
C91 down wire_cref 9.7650390625000004e-15
C92 T012_G wire_cref 4.0935600585937507e-15
C93 T030_G wire_cref 4.4213515625000001e-15
C94 T003_D wire_cref 2.6616252441406251e-15
C95 T002_D wire_cref 3.0848603515625001e-15
C96 T007_D wire_cref 2.3489265136718749e-15
C97 T006_D wire_cref 1.9289678955078125e-15
C98 T006_G wire_cref 2.3653713378906252e-15
C99 T005_G wire_cref 2.7089660644531252e-15
C100 avss wire_cref 2.1547255859374999e-15
C101 T009_S wire_cref 1.7927052001953129e-15
C102 T008_S wire_cref 1.7927052001953129e-15
C103 T007_S wire_cref 1.7927052001953129e-15
C104 T004_mim_btm wire_cref 8.7727158203125012e-15
C105 T002_S wire_cref 1.7927052001953129e-15
C106 T001_rppd_2 wire_cref 1.3859892578125e-15
C107 vctrl wire_cref 5.3249438476562511e-15
C108 T030_D wire_cref 1.9051671142578127e-15
C109 T012_D wire_cref 1.9051671142578127e-15
C110 T010_rppd_2 wire_cref 1.2402750244140627e-15
C111 T004_mim_top wire_cref 8.4986093750000004e-15
C112 T001_rppd_1 wire_cref 2.5073164062500003e-15
C113 T011_rppd_2 wire_cref 1.6195378417968751e-15
C114 T009_D wire_cref 2.1934968261718754e-15
C115 T009_G wire_cref 2.6303696289062505e-15
C116 T008_G wire_cref 4.9215849609375009e-15
C117 T007_G wire_cref 2.6303696289062505e-15
C118 T011_rppd_2.n0 wire_cref 1.0521833419799805e-17
C119 T011_rppd_2.n1 wire_cref 9.3223749999999999e-15
C120 T011_rppd_2.n2 wire_cref 5.6783022460937505e-15
C121 T011_rppd_2.n3 wire_cref 1.6825244140624999e-14
C122 P_vctrl.n0 wire_cref 1.0848278320312501e-14
C123 P_vctrl.n1 wire_cref 8.9465117187500002e-15
C124 P_vctrl.n2 wire_cref 6.4258168945312507e-15
C125 P_vctrl.n3 wire_cref 1.00728125e-14
C126 P_avss.n0 wire_cref 7.4686069335937508e-15
C127 P_avss.n1 wire_cref 1.02599560546875e-14
C128 P_avss.n2 wire_cref 1.1239376953125e-14
C129 P_avss.n3 wire_cref 8.3990566406250006e-15
C130 P_avss.n4 wire_cref 9.1520478515625012e-15
C131 T007_D.n0 wire_cref 1.0889233398437502e-14
C132 T007_D.n1 wire_cref 9.8925351562500003e-15
C133 T030_G.n0 wire_cref 9.7139062881469738e-18
C134 T030_G.n1 wire_cref 2.3673148437500002e-14
C135 P_div_avdd.n0 wire_cref 7.4698085937500002e-15
C136 P_div_avdd.n1 wire_cref 7.1681791992187506e-15
C137 P_div_avdd.n2 wire_cref 4.7922700195312502e-15
C138 P_div_avdd.n3 wire_cref 5.104009765625001e-15
C139 P_div_avdd.n4 wire_cref 5.0591733398437502e-15
C140 P_div_avdd.n5 wire_cref 7.194398437500001e-15
C141 P_div_avdd.n6 wire_cref 1.0980203125e-14
C142 P_up.n0 wire_cref 1.3663580078125e-14
C143 P_sub.n0 wire_cref 9.561212890625002e-15
C144 P_sub.n1 wire_cref 8.4395458984374996e-15
C145 P_sub.n2 wire_cref 8.4395458984374996e-15
C146 P_sub.n3 wire_cref 8.8904257812500017e-15
C147 P_sub.n4 wire_cref 8.8904257812500017e-15
C148 P_sub.n5 wire_cref 8.8904257812500017e-15
C149 P_sub.n6 wire_cref 8.4395458984374996e-15
C150 P_sub.n7 wire_cref 8.4395458984374996e-15
C151 P_sub.n8 wire_cref 8.8904257812500017e-15
C152 P_sub.n9 wire_cref 8.4395458984374996e-15
C153 P_sub.n10 wire_cref 8.8904257812500017e-15
C154 P_sub.n11 wire_cref 1.6132228515624999e-14
.ends nssoc_pump30_wire_v1
