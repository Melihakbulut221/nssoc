* SPDX-FileCopyrightText: 2026 Hasan Melih Akbulut
* SPDX-License-Identifier: CERN-OHL-W-2.0
* Eight-device feedback candidate with 10 um output PMOS; full PLL validation is pending.
.subckt nssoc_pll_feedback_levelshift_parallel8_pbuf10_v1 d db q qb avdd avss sub
* Real cross-coupled HV PMOS with LV-driven HV NMOS; no voltage gain source.
XPL qb right avdd avdd sg13_hv_pmos w=2u l=0.45u ng=1 m=1
XPR right qb avdd avdd sg13_hv_pmos w=2u l=0.45u ng=1 m=1
XNLA qb d avss sub sg13_hv_nmos w=8u l=0.45u ng=1 m=1
XNLB qb d avss sub sg13_hv_nmos w=8u l=0.45u ng=1 m=1
XNRA right db avss sub sg13_hv_nmos w=8u l=0.45u ng=1 m=1
XNRB right db avss sub sg13_hv_nmos w=8u l=0.45u ng=1 m=1
XPBUF q qb avdd avdd sg13_hv_pmos w=10u l=0.45u ng=1 m=1
XNBUF q qb avss sub sg13_hv_nmos w=4u l=0.45u ng=1 m=1
.ends nssoc_pll_feedback_levelshift_parallel8_pbuf10_v1
