* SPDX-FileCopyrightText: 2026 Hasan Melih Akbulut
* SPDX-License-Identifier: CERN-OHL-W-2.0
* Separate v2: lower DC loading, stronger real MIM interstage AC coupling.
* The first core retains its upward common-mode network. The second network
* lowers the first core's high output common mode; no ideal level shift.
.subckt nssoc_clock_div4_hbt_v2 clkp clkn qp qn avdd avss sub
XFIRST clkp clkn s1p s1n avdd avss sub nssoc_clock_div2_conditioned_hbt
XSP s1p ckp sub rppd w=2u l=8u b=0 sw_et=1
XSN s1n ckn sub rppd w=2u l=8u b=0 sw_et=1
XDP ckp avss sub rppd w=1u l=6u b=0 sw_et=1
XDN ckn avss sub rppd w=1u l=6u b=0 sw_et=1
XCP s1p ckp cap_cmim w=20u l=20u
XCN s1n ckn cap_cmim w=20u l=20u
XSECOND ckp ckn qp qn avdd avss sub nssoc_clock_div2_hbt
.ends nssoc_clock_div4_hbt_v2
