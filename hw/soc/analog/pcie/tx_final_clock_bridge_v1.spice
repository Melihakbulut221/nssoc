* SPDX-FileCopyrightText: 2026 Hasan Melih Akbulut
* SPDX-License-Identifier: CERN-OHL-W-2.0
* Fixed physical differential clock-load candidate; no electrical acceptance.
.subckt nssoc_tx_final_clock_bridge_v1 sp sn sub
XBRIDGE sp sn sub rppd w=6u l=1.2u b=0 sw_et=1
.ends nssoc_tx_final_clock_bridge_v1
